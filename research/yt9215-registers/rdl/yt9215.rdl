// Generated by tools/generate.py from yt921x.yaml. Do not edit.
//
// SystemRDL 2.0. Registers wider than 32 bits are read and written as
// 32-bit words, low word at the lower address. The addresses are those
// of the switch register space, reached indirectly over MDIO.

addrmap yt9215 {
    name = "Motorcomm YT921x Gigabit Ethernet switch family, YT9215 family";
    desc = "Parts: YT9215SC, YT9215S, YT9215RB, YT9214NB, YT9213NB.";
    default regwidth = 32;
    default accesswidth = 32;
    addressing = regalign;
    lsb0;

    reg {
        name = "External MDIO master start";
        desc = "Starts a transfer on the external MDIO master and shows when it has finished; see MDIO master transfer.";
        field { desc = "Write 1 to start the transfer set up in EXT_MBUS_CTRL. Reads 1 until the transfer is complete."; sw = rw; hw = r; } START[0:0];
    } EXT_MBUS_OP @ 0x6A000;

    reg {
        name = "External MDIO master command";
        desc = "Address and direction of the next transfer on the external MDIO pins.";
        enum ext_mbus_ctrl_type_e {
            C22 = 4 { desc = "IEEE 802.3 clause 22 frame"; };
        };
        enum ext_mbus_ctrl_op_e {
            WRITE = 1 { desc = "Write the register"; };
            READ = 2 { desc = "Read the register"; };
        };
        field { desc = "PHY address from 0 to 31. On the internal bus it equals the port number."; sw = rw; hw = r; } PORT[25:21];
        field { desc = "PHY register number from 0 to 31."; sw = rw; hw = r; } REG[20:16];
        field { desc = "Frame format. The comment on the field reads \"wild guess\", so the width of the field is inferred."; sw = rw; hw = r; encode = ext_mbus_ctrl_type_e; } TYPE[11:8];
        field { desc = "Direction. The comment on the field reads \"wild guess\", so the width of the field is inferred."; sw = rw; hw = r; encode = ext_mbus_ctrl_op_e; } OP[3:2];
    } EXT_MBUS_CTRL @ 0x6A004;

    reg {
        name = "External MDIO master write data";
        desc = "Data for the next write transfer on the external MDIO master.";
        field { desc = "The 16-bit PHY register value."; sw = rw; hw = r; } DATA[15:0];
    } EXT_MBUS_DOUT @ 0x6A008;

    reg {
        name = "External MDIO master read data";
        desc = "Data returned by the last read transfer on the external MDIO master.";
        field { desc = "The 16-bit PHY register value."; sw = r; hw = w; } DATA[15:0];
    } EXT_MBUS_DIN @ 0x6A00C;

    reg {
        name = "Reset control";
        desc = "Starts a reset of the switch. Write RST.HW and poll the register until it reads 0; Reset gives the full sequence.";
        field { desc = "Write 1 to reset the whole chip. The bit clears itself when the reset is complete. Section 4.1.2.1 of the YT9215SCH datasheet calls the bit CHIP_RESET."; sw = rw; hw = r; } HW[31:31];
        field { desc = "Write 1 for a software reset. Section 4.1.2.2 of the YT9215SCH datasheet calls the bit SW_RESET. It states that the bit clears itself and resets what RST.HW resets except the analog circuit of the built-in PHYs. No function of the Linux driver uses the bit."; sw = rw; hw = r; } SW[1:1];
    } RST @ 0x80000;

    reg {
        name = "Function enables";
        desc = "Enable bits of three function blocks. :ref:`bringup-features` gives the evidence for their effect. The vendor SDK names a fourth enable bit, AC_EN in bit 3, which this manual does not describe.";
        field { desc = "Enable bit of the meters, whose registers are METER_CTRL and PORT_METER. yt921x_chip_setup sets the bit, and the vendor SDK function fal_tiger_rate_init() writes it as an enable. It is inferred that the block works only while the bit is set."; sw = rw; hw = r; } METER[4:4];
        field { desc = "Enable bit of the access control list, whose registers include ACL_KEY and ACL_ACT. yt921x_chip_setup sets the bit, and the vendor SDK function fal_tiger_acl_global_enable() writes it as an enable. It is inferred that the block works only while the bit is set."; sw = rw; hw = r; } ACL[2:2];
        field { desc = "Enable bit of the port counters of MIB_DATA. yt921x_chip_setup sets the bit, and the vendor SDK function fal_tiger_stat_mib_enable_set() writes it as an enable. It is inferred that the block works only while the bit is set."; sw = rw; hw = r; } MIB[1:1];
    } FUNC @ 0x80004;

    reg {
        name = "Chip identification";
        desc = "Identifies the chip family. Read it before the reset, as described in Find the switch.";
        field { desc = "Family code. 0x9002 is the YT9215 family and 0x9001 the YT9218 family."; sw = r; hw = w; } MAJOR[31:16];
        field { desc = "Lower half of the chip ID. The file fal_tiger_init.c of the vendor SDK tests it for the value 1. The meaning of its values is not known."; sw = r; hw = w; } MINOR[15:0];
    } CHIP_ID @ 0x80008;

    reg {
        name = "External CPU port";
        desc = "Names the port that leads to the host CPU and turns CPU tagging on for it; see CPU port and frame tag.";
        field { desc = "Frames to and from the CPU port carry the 8-byte CPU tag."; sw = rw; hw = r; } TAG_EN[15:15];
        field { desc = "EXT_CPU_PORT.PORT is valid and that port is treated as the CPU port."; sw = rw; hw = r; } PORT_EN[14:14];
        field { desc = "Number of the CPU port from 0 to 10."; sw = rw; hw = r; } PORT[3:0];
    } EXT_CPU_PORT @ 0x8000C;

    reg {
        name = "CPU tag EtherType";
        desc = "EtherType that opens the CPU tag. Reading the reset value back is a cheap check that register access works.";
        field { desc = "EtherType of the CPU tag."; sw = rw; hw = r; } TPID[15:0];
    } CPU_TAG_TPID @ 0x80010;

    reg {
        name = "Lookup VLAN select";
        desc = "Chooses, per port, which VLAN tag selects the VLAN table entry.";
        field { desc = "Port port looks frames up by the service VLAN ID. It does not use the customer VLAN ID."; sw = rw; hw = r; } SVID_PORT_10[10:10];
        field { desc = "Port port looks frames up by the service VLAN ID. It does not use the customer VLAN ID."; sw = rw; hw = r; } SVID_PORT_9[9:9];
        field { desc = "Port port looks frames up by the service VLAN ID. It does not use the customer VLAN ID."; sw = rw; hw = r; } SVID_PORT_8[8:8];
        field { desc = "Port port looks frames up by the service VLAN ID. It does not use the customer VLAN ID."; sw = rw; hw = r; } SVID_PORT_7[7:7];
        field { desc = "Port port looks frames up by the service VLAN ID. It does not use the customer VLAN ID."; sw = rw; hw = r; } SVID_PORT_6[6:6];
        field { desc = "Port port looks frames up by the service VLAN ID. It does not use the customer VLAN ID."; sw = rw; hw = r; } SVID_PORT_5[5:5];
        field { desc = "Port port looks frames up by the service VLAN ID. It does not use the customer VLAN ID."; sw = rw; hw = r; } SVID_PORT_4[4:4];
        field { desc = "Port port looks frames up by the service VLAN ID. It does not use the customer VLAN ID."; sw = rw; hw = r; } SVID_PORT_3[3:3];
        field { desc = "Port port looks frames up by the service VLAN ID. It does not use the customer VLAN ID."; sw = rw; hw = r; } SVID_PORT_2[2:2];
        field { desc = "Port port looks frames up by the service VLAN ID. It does not use the customer VLAN ID."; sw = rw; hw = r; } SVID_PORT_1[1:1];
        field { desc = "Port port looks frames up by the service VLAN ID. It does not use the customer VLAN ID."; sw = rw; hw = r; } SVID_PORT_0[0:0];
    } PVID_SEL @ 0x80014;

    reg {
        name = "SerDes enable";
        desc = "Enables the SGMII SerDes of ports 8 and 9, as yt921x_port_config does. A port uses either its SerDes or its xMII pins; clear the matching bit in XMII_CTRL when setting one here.";
        field { desc = "yt921x_chip_setup clears the bit. It is inferred from the name that the bit selects a test mode of the SerDes. The file fal_tiger_init.c of the vendor SDK clears the bit together with the two port bits under a comment with the lines \"disable sds intf,will be enabled when config sds mode\" and \"set to mdio access mode\"."; sw = rw; hw = r; } TEST[6:6];
        field { desc = "Bit 0 enables the SerDes of port 8. Bit 1 enables the SerDes of port 9."; sw = rw; hw = r; } PORT_9[1:1];
        field { desc = "Bit 0 enables the SerDes of port 8. Bit 1 enables the SerDes of port 9."; sw = rw; hw = r; } PORT_8[0:0];
    } SERDES_CTRL @ 0x80028;

    reg {
        name = "I/O voltage select";
        desc = "Sets the signalling voltage of the digital pins. The field positions differ between the YT9215 and YT9218 families.";
        enum io_level_normal_e {
            V3V3 = 0 { desc = "3.3 V"; };
            V1V8 = 3 { desc = "1.8 V"; };
        };
        enum io_level_rgmii1_e {
            V3V3 = 0 { desc = "3.3 V"; };
            V2V5 = 1 { desc = "2.5 V"; };
            V1V8 = 2 { desc = "1.8 V"; };
        };
        enum io_level_rgmii0_e {
            V3V3 = 0 { desc = "3.3 V"; };
            V2V5 = 1 { desc = "2.5 V"; };
            V1V8 = 2 { desc = "1.8 V"; };
        };
        field { desc = "Voltage of the general digital I/O pins."; sw = rw; hw = r; encode = io_level_normal_e; } NORMAL[5:4];
        field { desc = "Voltage of the second xMII interface pins."; sw = rw; hw = r; encode = io_level_rgmii1_e; } RGMII1[3:2];
        field { desc = "Voltage of the first xMII interface pins."; sw = rw; hw = r; encode = io_level_rgmii0_e; } RGMII0[1:0];
    } IO_LEVEL @ 0x80030;

    reg {
        name = "Switch MAC address, high part";
        desc = "Two bytes of the MAC address of the switch. It is inferred from the name that the switch uses the address as the source address of frames it sends itself, such as pause frames. :ref:`bringup-mac` gives the two readings of the byte order.";
        field { desc = "Two bytes of the MAC address. The register name reads as the first two bytes of the address, which is inferred. The vendor SDK reads the field as the last two bytes, with byte 4 in bits 15 to 8. It is not known which is right."; sw = rw; hw = r; } ADDR[15:0];
    } MAC_ADDR_HI2 @ 0x80080;

    reg {
        name = "Switch MAC address, low part";
        desc = "Four bytes of the MAC address of the switch; see MAC_ADDR_HI2.";
        field { desc = "Four bytes of the MAC address. The register name reads as the last four bytes of the address, which is inferred. The vendor SDK reads the field as the first four bytes, with byte 0 in bits 31 to 24. It is not known which is right."; sw = rw; hw = r; } ADDR[31:0];
    } MAC_ADDR_LO4 @ 0x80084;

    reg {
        name = "SerDes mode and forced link";
        desc = "Protocol of one SerDes and, when the link is not negotiated in-band, its forced link settings. The SerDes PCS registers themselves are standard MDIO registers reached through the internal MDIO master at the address of the port number. Index: port = 8 to 9.";
        enum serdes_mode_e {
            SGMII = 0 { desc = "SGMII as the MAC side"; };
            REVSGMII = 1 { desc = "SGMII as the PHY side"; };
            V1000BASEX = 2 { desc = "1000BASE-X"; };
            V100BASEX = 3 { desc = "100BASE-FX fibre mode"; };
            V2500BASEX = 4 { desc = "2500BASE-X"; };
        };
        enum serdes_speed_e {
            V10 = 0 { desc = "10 Mbit/s"; };
            V100 = 1 { desc = "100 Mbit/s"; };
            V1000 = 2 { desc = "1000 Mbit/s"; };
            V10000 = 3 { desc = "10000 Mbit/s"; };
            V2500 = 4 { desc = "2500 Mbit/s"; };
        };
        field { desc = "SerDes protocol."; sw = rw; hw = r; encode = serdes_mode_e; } MODE[9:7];
        field { desc = "Forced receive pause."; sw = rw; hw = r; } RX_PAUSE[6:6];
        field { desc = "Forced transmit pause."; sw = rw; hw = r; } TX_PAUSE[5:5];
        field { desc = "Forces the link up."; sw = rw; hw = r; } LINK[4:4];
        field { desc = "Forced full duplex."; sw = rw; hw = r; } DUPLEX_FULL[3:3];
        field { desc = "Forced speed."; sw = rw; hw = r; encode = serdes_speed_e; } SPEED[2:0];
    } SERDES[2] @ 0x8008C += 0x4;

    reg {
        name = "Port control";
        desc = "Forces or negotiates the MAC settings of one port. Bits 7 to 0 have the same layout as PORT_STATUS; it is inferred from the name of PORT_CTRL.LINK_AN that with the bit clear the MAC uses the values written here. Bring a port up gives the order of writes. Index: port = 0 to 10.";
        enum port_ctrl_speed_e {
            V10 = 0 { desc = "10 Mbit/s"; };
            V100 = 1 { desc = "100 Mbit/s"; };
            V1000 = 2 { desc = "1000 Mbit/s"; };
            V10000 = 3 { desc = "10000 Mbit/s"; };
            V2500 = 4 { desc = "2500 Mbit/s"; };
        };
        field { desc = "yt921x_serdes_config sets the bit for a SerDes link with in-band negotiation other than SGMII whose pause result the MAC may take. It is inferred from the name that the MAC then takes the pause settings from in-band negotiation and ignores PORT_CTRL.RX_PAUSE and PORT_CTRL.TX_PAUSE."; sw = rw; hw = r; } PAUSE_AN[10:10];
        field { desc = "yt921x_serdes_config sets the bit for a SerDes link with in-band status. It is inferred from the name that the MAC then takes speed and duplex from the in-band status, that the bit also follows a built-in PHY and that the forced bits are then ignored."; sw = rw; hw = r; } LINK_AN[9:9];
        field { desc = "Use back pressure for flow control in half duplex."; sw = rw; hw = r; } HALF_PAUSE[8:8];
        field { desc = "Forced full duplex."; sw = rw; hw = r; } DUPLEX_FULL[7:7];
        field { desc = "Honour received pause frames."; sw = rw; hw = r; } RX_PAUSE[6:6];
        field { desc = "Send pause frames when the port is congested."; sw = rw; hw = r; } TX_PAUSE[5:5];
        field { desc = "Enables the receive side of the MAC."; sw = rw; hw = r; } RX_MAC_EN[4:4];
        field { desc = "Enables the transmit side of the MAC."; sw = rw; hw = r; } TX_MAC_EN[3:3];
        field { desc = "Forced speed."; sw = rw; hw = r; encode = port_ctrl_speed_e; } SPEED[2:0];
    } PORT_CTRL[11] @ 0x80100 += 0x4;

    reg {
        name = "Port status";
        desc = "Link state and the MAC settings one port is running with. Index: port = 0 to 10.";
        enum port_status_speed_e {
            V10 = 0 { desc = "10 Mbit/s"; };
            V100 = 1 { desc = "100 Mbit/s"; };
            V1000 = 2 { desc = "1000 Mbit/s"; };
            V10000 = 3 { desc = "10000 Mbit/s"; };
            V2500 = 4 { desc = "2500 Mbit/s"; };
        };
        field { desc = "1 while the link is up."; sw = r; hw = w; } LINK[8:8];
        field { desc = "1 for full duplex."; sw = r; hw = w; } DUPLEX_FULL[7:7];
        field { desc = "Receive pause is active."; sw = r; hw = w; } RX_PAUSE[6:6];
        field { desc = "Transmit pause is active."; sw = r; hw = w; } TX_PAUSE[5:5];
        field { desc = "The receive side of the MAC is enabled."; sw = r; hw = w; } RX_MAC_EN[4:4];
        field { desc = "The transmit side of the MAC is enabled."; sw = r; hw = w; } TX_MAC_EN[3:3];
        field { desc = "Current speed."; sw = r; hw = w; encode = port_status_speed_e; } SPEED[2:0];
    } PORT_STATUS[11] @ 0x80200 += 0x4;

    reg {
        name = "Pin strap override enable";
        desc = "Selects, per function, whether the switch uses the level sampled on the strap pin at power-on (bit clear) or the value in PON_STRAP_VAL (bit set). This split between the two registers is inferred from their names. yt921x_set_eee writes the same value to the EEE bit of both.";
        field { desc = "Take the Energy Efficient Ethernet setting from PON_STRAP_VAL.EEE. yt921x_set_eee sets this bit together with PON_STRAP_VAL.EEE to turn the function on; the role of each bit alone is inferred from the register names."; sw = rw; hw = r; } EEE[16:16];
        field { desc = "Take the loop detection setting from PON_STRAP_VAL.LOOP_DETECT."; sw = rw; hw = r; } LOOP_DETECT[7:7];
    } PON_STRAP_FUNC @ 0x80320;

    reg {
        name = "Pin strap override value";
        desc = "It is inferred from the register names that the switch uses these values in place of the power-on straps for every function whose bit is set in PON_STRAP_FUNC.";
        field { desc = "1 turns Energy Efficient Ethernet on. yt921x_set_eee sets this bit together with PON_STRAP_FUNC.EEE; the role of each bit alone is inferred from the register names."; sw = rw; hw = r; } EEE[16:16];
        field { desc = "Loop detection strap value. The vendor SDK function fal_tiger_loop_detect_enable_set() clears this bit and sets PON_STRAP_FUNC.LOOP_DETECT to turn loop detection on, and its comment calls the strap \"dis lpd strap\". By that code 1 turns loop detection off."; sw = rw; hw = r; } LOOP_DETECT[7:7];
    } PON_STRAP_VAL @ 0x80324;

    reg {
        name = "Pin strap capture";
        desc = "Levels that were sampled on the strap pins at power-on.";
        field { desc = "Captured Energy Efficient Ethernet strap."; sw = r; hw = w; } EEE[16:16];
        field { desc = "Captured loop detection strap."; sw = r; hw = w; } LOOP_DETECT[7:7];
    } PON_STRAP_CAP @ 0x80328;

    reg {
        name = "External port link override";
        desc = "Link state of port 8 or 9. yt921x_port_up writes the link state here for an external port that does not use its SerDes. It is inferred from the name that the switch otherwise learns the state by polling a PHY on the external MDIO bus. Index: port = 8 to 9.";
        enum mdio_polling_speed_e {
            V10 = 0 { desc = "10 Mbit/s"; };
            V100 = 1 { desc = "100 Mbit/s"; };
            V1000 = 2 { desc = "1000 Mbit/s"; };
            V10000 = 3 { desc = "10000 Mbit/s"; };
            V2500 = 4 { desc = "2500 Mbit/s"; };
        };
        field { desc = "1 for full duplex."; sw = rw; hw = r; } DUPLEX_FULL[4:4];
        field { desc = "1 for link up."; sw = rw; hw = r; } LINK[3:3];
        field { desc = "Link speed."; sw = rw; hw = r; encode = mdio_polling_speed_e; } SPEED[2:0];
    } MDIO_POLLING[2] @ 0x80364 += 0x4;

    reg {
        name = "Sensor enable";
        desc = "Enables the on-chip sensors.";
        field { desc = "Enables the temperature sensor that TEMP reads."; sw = rw; hw = r; } TEMP[18:18];
    } SENSOR @ 0x8036C;

    reg {
        name = "Temperature sensor reading";
        desc = "Reading of the temperature sensor. No function of the Linux driver reads the register. :ref:`bringup-temp` gives the conversion that the vendor SDK uses.";
        field { desc = "Sensor value. The vendor SDK function fal_tiger_sensor_temp_value_get() uses bits 15 to 0, in steps of 1/128 °C."; sw = r; hw = w; } VALUE[31:0];
    } TEMP @ 0x80374;

    reg {
        name = "Package variant";
        desc = "Tells the parts of one family apart. :ref:`reference-parts` lists the value of each part.";
        field { desc = "Package variant code."; sw = r; hw = w; } MODE[1:0];
    } CHIP_MODE @ 0x80388;

    reg {
        name = "xMII enable";
        desc = "Selects the parallel MAC interface (MII, RMII or RGMII) pins of ports 8 and 9. The bit order is the reverse of the port order. yt921x_port_config clears the bit of a port that uses its SerDes. The vendor SDK function fal_tiger_port_extif_mode_set() sets the bit for an xMII mode, under the comment \"select xmii mode\".";
        field { desc = "Bit 1 selects the xMII pins of port 8. Bit 0 selects the xMII pins of port 9."; sw = rw; hw = r; } PORT_8[1:1];
        field { desc = "Bit 1 selects the xMII pins of port 8. Bit 0 selects the xMII pins of port 9."; sw = rw; hw = r; } PORT_9[0:0];
    } XMII_CTRL @ 0x80394;

    reg {
        name = "xMII mode and timing";
        desc = "Mode, clock direction and RGMII delays of one parallel MAC interface. Index: port = 8 to 9.";
        enum xmii_mode_e {
            MII = 0 { desc = "MII as the MAC side"; };
            REVMII = 1 { desc = "MII as the PHY side"; };
            RMII = 2 { desc = "RMII as the MAC side"; };
            REVRMII = 3 { desc = "RMII as the PHY side"; };
            RGMII = 4 { desc = "RGMII"; };
            DISABLE = 5 { desc = "Interface off"; };
        };
        field { desc = "Interface type."; sw = rw; hw = r; encode = xmii_mode_e; } MODE[31:29];
        field { desc = "Forces the link of the interface up."; sw = rw; hw = r; } LINK[19:19];
        field { desc = "Enables the interface."; sw = rw; hw = r; } EN[18:18];
        field { desc = "Resets the interface logic."; sw = rw; hw = r; } SOFT_RST[17:17];
        field { desc = "Fine RGMII transmit clock delay in steps of 150 ps. A comment in fal_tiger_port.c of the vendor SDK gives the transmit clock delay as 2 ns times XMII.RGMII_TX_DELAY_2NS plus 0.15 ns times this field."; sw = rw; hw = r; } RGMII_TX_DELAY_150PS[16:13];
        field { desc = "The Linux name reads as: the transmit clock pin is an input. The vendor SDK names the bit XMII_TXC_IN_SEL, and its function fal_tiger_port_extif_xmiiClk_invert_set() writes the bit as the enable of an inverted xMII clock. The two readings disagree, and it is not known which is right."; sw = rw; hw = r; } TX_CLK_IN[11:11];
        field { desc = "The receive clock pin is an input."; sw = rw; hw = r; } RX_CLK_IN[10:10];
        field { desc = "Adds 2 ns to the delay of the RGMII transmit clock, by the comment in fal_tiger_port.c of the vendor SDK."; sw = rw; hw = r; } RGMII_TX_DELAY_2NS[8:8];
        field { desc = "Drives the RGMII transmit clock."; sw = rw; hw = r; } RGMII_TX_CLK_OUT[7:7];
        field { desc = "RGMII receive clock delay in steps of 150 ps, by the comment in fal_tiger_port.c of the vendor SDK."; sw = rw; hw = r; } RGMII_RX_DELAY_150PS[6:3];
        field { desc = "Drives the RMII reference clock when the switch is the PHY side."; sw = rw; hw = r; } RMII_PHY_TX_CLK_OUT[2:2];
        field { desc = "Drives the MII transmit clock when the switch is the PHY side."; sw = rw; hw = r; } REVMII_TX_CLK_OUT[1:1];
        field { desc = "Drives the MII receive clock when the switch is the PHY side."; sw = rw; hw = r; } REVMII_RX_CLK_OUT[0:0];
    } XMII[2] @ 0x80400 += 0x8;

    reg {
        name = "MAC frame size";
        desc = "Largest frame the MAC of one port accepts. Index: port = 0 to 10.";
        field { desc = "Maximum frame length in bytes. The length counts from the destination address to the frame check sequence. The largest value is 0x2400 (9216)."; sw = rw; hw = r; } SIZE[21:8];
    } MAC_FRAME[11] @ 0x81008 += 0x1000;

    reg {
        name = "Port EEE value";
        desc = "Per-port Energy Efficient Ethernet bit that yt921x_set_eee sets and clears together with EEE_CTRL.EN of the port. It is not known what the bit does alone. Index: port = 0 to 10.";
        field { desc = "Set to turn Energy Efficient Ethernet on for the port and cleared to turn it off, as yt921x_set_eee does."; sw = rw; hw = r; } DATA[1:1];
    } EEE_VAL[11] @ 0xA0000 += 0x40;

    reg {
        name = "EEE port enable";
        desc = "One Energy Efficient Ethernet enable bit per port; see Energy Efficient Ethernet.";
        field { desc = "Enables Energy Efficient Ethernet on port port."; sw = rw; hw = r; } EN_10[10:10];
        field { desc = "Enables Energy Efficient Ethernet on port port."; sw = rw; hw = r; } EN_9[9:9];
        field { desc = "Enables Energy Efficient Ethernet on port port."; sw = rw; hw = r; } EN_8[8:8];
        field { desc = "Enables Energy Efficient Ethernet on port port."; sw = rw; hw = r; } EN_7[7:7];
        field { desc = "Enables Energy Efficient Ethernet on port port."; sw = rw; hw = r; } EN_6[6:6];
        field { desc = "Enables Energy Efficient Ethernet on port port."; sw = rw; hw = r; } EN_5[5:5];
        field { desc = "Enables Energy Efficient Ethernet on port port."; sw = rw; hw = r; } EN_4[4:4];
        field { desc = "Enables Energy Efficient Ethernet on port port."; sw = rw; hw = r; } EN_3[3:3];
        field { desc = "Enables Energy Efficient Ethernet on port port."; sw = rw; hw = r; } EN_2[2:2];
        field { desc = "Enables Energy Efficient Ethernet on port port."; sw = rw; hw = r; } EN_1[1:1];
        field { desc = "Enables Energy Efficient Ethernet on port port."; sw = rw; hw = r; } EN_0[0:0];
    } EEE_CTRL @ 0xB0000;

    reg {
        name = "Counter control";
        desc = "Clears port counters.";
        field { desc = "Write 1 to clear the selected counters."; sw = rw; hw = r; } CLEAN[30:30];
        field { desc = "Port whose counters are cleared when MIB_CTRL.ONE_PORT is set."; sw = rw; hw = r; } PORT[6:3];
        field { desc = "Clear the counters of the port in MIB_CTRL.PORT."; sw = rw; hw = r; } ONE_PORT[1:1];
        field { desc = "It is inferred from the name that the bit clears the counters of every port. The vendor SDK function fal_tiger_stat_mib_clear_all() leaves the bit at 0 for a clear of every port."; sw = rw; hw = r; } ALL_PORT[0:0];
    } MIB_CTRL @ 0xC0004;

    regfile {
        name = "Port counter block";
        desc = "Start of the counter block of one port. Each counter sits at a fixed byte offset inside the block, listed in Port counters.";
        reg {
            desc = "Broadcast frames received";
            field { desc = "Broadcast frames received"; sw = r; hw = w; } COUNT[31:0];
        } RX_BROADCAST @ 0x00;
        reg {
            desc = "Pause frames received";
            field { desc = "Pause frames received"; sw = r; hw = w; } COUNT[31:0];
        } RX_PAUSE @ 0x04;
        reg {
            desc = "Multicast frames received";
            field { desc = "Multicast frames received"; sw = r; hw = w; } COUNT[31:0];
        } RX_MULTICAST @ 0x08;
        reg {
            desc = "Frames received with a bad frame check sequence";
            field { desc = "Frames received with a bad frame check sequence"; sw = r; hw = w; } COUNT[31:0];
        } RX_CRC_ERR @ 0x0C;
        reg {
            desc = "Frames received with an alignment error";
            field { desc = "Frames received with an alignment error"; sw = r; hw = w; } COUNT[31:0];
        } RX_ALIGN_ERR @ 0x10;
        reg {
            desc = "Frames received shorter than 64 bytes with a good frame check sequence";
            field { desc = "Frames received shorter than 64 bytes with a good frame check sequence"; sw = r; hw = w; } COUNT[31:0];
        } RX_UNDERSIZE_ERR @ 0x14;
        reg {
            desc = "Frames received shorter than 64 bytes with a bad frame check sequence";
            field { desc = "Frames received shorter than 64 bytes with a bad frame check sequence"; sw = r; hw = w; } COUNT[31:0];
        } RX_FRAG_ERR @ 0x18;
        reg {
            desc = "Frames received with a length of 64 bytes";
            field { desc = "Frames received with a length of 64 bytes"; sw = r; hw = w; } COUNT[31:0];
        } RX_PKT_SZ_64 @ 0x1C;
        reg {
            desc = "Frames received with a length of 65 to 127 bytes";
            field { desc = "Frames received with a length of 65 to 127 bytes"; sw = r; hw = w; } COUNT[31:0];
        } RX_PKT_SZ_65_TO_127 @ 0x20;
        reg {
            desc = "Frames received with a length of 128 to 255 bytes";
            field { desc = "Frames received with a length of 128 to 255 bytes"; sw = r; hw = w; } COUNT[31:0];
        } RX_PKT_SZ_128_TO_255 @ 0x24;
        reg {
            desc = "Frames received with a length of 256 to 511 bytes";
            field { desc = "Frames received with a length of 256 to 511 bytes"; sw = r; hw = w; } COUNT[31:0];
        } RX_PKT_SZ_256_TO_511 @ 0x28;
        reg {
            desc = "Frames received with a length of 512 to 1023 bytes";
            field { desc = "Frames received with a length of 512 to 1023 bytes"; sw = r; hw = w; } COUNT[31:0];
        } RX_PKT_SZ_512_TO_1023 @ 0x2C;
        reg {
            desc = "Frames received with a length of 1024 to 1518 bytes";
            field { desc = "Frames received with a length of 1024 to 1518 bytes"; sw = r; hw = w; } COUNT[31:0];
        } RX_PKT_SZ_1024_TO_1518 @ 0x30;
        reg {
            desc = "Frames received longer than 1518 bytes";
            field { desc = "Frames received longer than 1518 bytes"; sw = r; hw = w; } COUNT[31:0];
        } RX_PKT_SZ_1519_TO_MAX @ 0x34;
        reg {
            desc = "Bytes received in good frames";
            regwidth = 64;
            field { desc = "Bytes received in good frames"; sw = r; hw = w; } COUNT[63:0];
        } RX_GOOD_BYTES @ 0x3C;
        reg {
            desc = "Bytes received in bad frames";
            regwidth = 64;
            field { desc = "Bytes received in bad frames"; sw = r; hw = w; } COUNT[63:0];
        } RX_BAD_BYTES @ 0x44;
        reg {
            desc = "Frames received longer than the frame size limit";
            field { desc = "Frames received longer than the frame size limit"; sw = r; hw = w; } COUNT[31:0];
        } RX_OVERSIZE_ERR @ 0x4C;
        reg {
            desc = "Received frames dropped by the switch";
            field { desc = "Received frames dropped by the switch"; sw = r; hw = w; } COUNT[31:0];
        } RX_DROPPED @ 0x50;
        reg {
            desc = "Broadcast frames sent";
            field { desc = "Broadcast frames sent"; sw = r; hw = w; } COUNT[31:0];
        } TX_BROADCAST @ 0x54;
        reg {
            desc = "Pause frames sent";
            field { desc = "Pause frames sent"; sw = r; hw = w; } COUNT[31:0];
        } TX_PAUSE @ 0x58;
        reg {
            desc = "Multicast frames sent";
            field { desc = "Multicast frames sent"; sw = r; hw = w; } COUNT[31:0];
        } TX_MULTICAST @ 0x5C;
        reg {
            desc = "Frames sent shorter than 64 bytes";
            field { desc = "Frames sent shorter than 64 bytes"; sw = r; hw = w; } COUNT[31:0];
        } TX_UNDERSIZE_ERR @ 0x60;
        reg {
            desc = "Frames sent with a length of 64 bytes";
            field { desc = "Frames sent with a length of 64 bytes"; sw = r; hw = w; } COUNT[31:0];
        } TX_PKT_SZ_64 @ 0x64;
        reg {
            desc = "Frames sent with a length of 65 to 127 bytes";
            field { desc = "Frames sent with a length of 65 to 127 bytes"; sw = r; hw = w; } COUNT[31:0];
        } TX_PKT_SZ_65_TO_127 @ 0x68;
        reg {
            desc = "Frames sent with a length of 128 to 255 bytes";
            field { desc = "Frames sent with a length of 128 to 255 bytes"; sw = r; hw = w; } COUNT[31:0];
        } TX_PKT_SZ_128_TO_255 @ 0x6C;
        reg {
            desc = "Frames sent with a length of 256 to 511 bytes";
            field { desc = "Frames sent with a length of 256 to 511 bytes"; sw = r; hw = w; } COUNT[31:0];
        } TX_PKT_SZ_256_TO_511 @ 0x70;
        reg {
            desc = "Frames sent with a length of 512 to 1023 bytes";
            field { desc = "Frames sent with a length of 512 to 1023 bytes"; sw = r; hw = w; } COUNT[31:0];
        } TX_PKT_SZ_512_TO_1023 @ 0x74;
        reg {
            desc = "Frames sent with a length of 1024 to 1518 bytes";
            field { desc = "Frames sent with a length of 1024 to 1518 bytes"; sw = r; hw = w; } COUNT[31:0];
        } TX_PKT_SZ_1024_TO_1518 @ 0x78;
        reg {
            desc = "Frames sent longer than 1518 bytes";
            field { desc = "Frames sent longer than 1518 bytes"; sw = r; hw = w; } COUNT[31:0];
        } TX_PKT_SZ_1519_TO_MAX @ 0x7C;
        reg {
            desc = "Bytes sent in good frames";
            regwidth = 64;
            field { desc = "Bytes sent in good frames"; sw = r; hw = w; } COUNT[63:0];
        } TX_GOOD_BYTES @ 0x84;
        reg {
            desc = "Collisions seen while sending";
            field { desc = "Collisions seen while sending"; sw = r; hw = w; } COUNT[31:0];
        } TX_COLLISION @ 0x8C;
        reg {
            desc = "Frames not sent after 16 collisions";
            field { desc = "Frames not sent after 16 collisions"; sw = r; hw = w; } COUNT[31:0];
        } TX_EXCESSIVE_COLLISION @ 0x90;
        reg {
            desc = "Frames sent after more than one collision";
            field { desc = "Frames sent after more than one collision"; sw = r; hw = w; } COUNT[31:0];
        } TX_MULTIPLE_COLLISION @ 0x94;
        reg {
            desc = "Frames sent after exactly one collision";
            field { desc = "Frames sent after exactly one collision"; sw = r; hw = w; } COUNT[31:0];
        } TX_SINGLE_COLLISION @ 0x98;
        reg {
            desc = "Good frames sent";
            field { desc = "Good frames sent"; sw = r; hw = w; } COUNT[31:0];
        } TX_PKT @ 0x9C;
        reg {
            desc = "Frames whose first transmit attempt was deferred";
            field { desc = "Frames whose first transmit attempt was deferred"; sw = r; hw = w; } COUNT[31:0];
        } TX_DEFERRED @ 0xA0;
        reg {
            desc = "Collisions seen later than 512 bit times into a frame";
            field { desc = "Collisions seen later than 512 bit times into a frame"; sw = r; hw = w; } COUNT[31:0];
        } TX_LATE_COLLISION @ 0xA4;
        reg {
            desc = "OAM frames received";
            field { desc = "OAM frames received"; sw = r; hw = w; } COUNT[31:0];
        } RX_OAM @ 0xA8;
        reg {
            desc = "OAM frames sent";
            field { desc = "OAM frames sent"; sw = r; hw = w; } COUNT[31:0];
        } TX_OAM @ 0xAC;
    } MIB[11] @ 0xC0100 += 0x100;

    reg {
        name = "LED global control";
        desc = "Chooses between parallel and serial LED outputs and sets the loop detection blink rate.";
        enum led_ctrl_mode_e {
            PARALLEL = 0 { desc = "One pin per LED"; };
            SERIAL = 2 { desc = "LED states shifted out on a clock and data pin pair"; };
        };
        field { desc = "The vendor SDK function fal_tiger_led_enable() sets the bit under the comment \"enabel LED\". The Linux driver does not name its function."; sw = rw; hw = r; } UNK[21:21];
        field { desc = "Blink cycle that signals a detected loop. The comment on the field gives the cycle as 512 ms times the field value. The vendor SDK list yt_led_loopdetect_blink_rate_t gives 512 ms for the value 0 and 2048 ms for the value 3, which is 512 ms times the field value plus one. It is not known which is right."; sw = rw; hw = r; } LOOPDETECT_BLINK[20:19];
        field { desc = "Number of ports shifted out in serial mode."; sw = rw; hw = r; } PORT_NUM[16:13];
        field { desc = "LED output mode."; sw = rw; hw = r; encode = led_ctrl_mode_e; } MODE[1:0];
    } LED_CTRL @ 0xD0000;

    reg {
        name = "LED group 0 behaviour";
        desc = "Conditions that light or blink LED 0 of one port. It is inferred from yt921x_led_trigger_set, which sets several bits at once, that each set bit adds one condition and that the LED shows the combination. LEDs explains the three LED groups. Index: port = 0 to 9.";
        field { desc = "Only LED 0 has the field. The vendor SDK action list names the bit LED_ACTION_DISABLE_LINK_TRY, and fal_tiger_led_action_set() sets it for LED 0 in every case, under the comment \"tiger must set disable_link_try bit to 1\". The Linux driver disagrees: yt921x_led_trigger_set writes LED 0 with a mask that holds this bit and never sets it, so it clears the bit. What the bit does is not known."; sw = rw; hw = r; } ACT_LINK_TRY_DIS[17:17];
        field { desc = "Only LED 0 has the field. The vendor SDK action list names the bit LED_ACTION_COLLISION_BLINK. It is inferred from the name that the LED blinks on a collision."; sw = rw; hw = r; } ACT_COLLISION_BLINK_INDI[16:16];
        field { desc = "Blink while the port is in low power idle."; sw = rw; hw = r; } ACT_EEE_BLINK[15:15];
        field { desc = "Blink when a loop is detected on the port."; sw = rw; hw = r; } ACT_LOOPDETECT_BLINK[14:14];
        field { desc = "Blink on any activity."; sw = rw; hw = r; } ACT_ACTIVE_BLINK[13:13];
        field { desc = "On while the link is up in full duplex."; sw = rw; hw = r; } ACT_DUPLEX_FULL[12:12];
        field { desc = "On while the link is up in half duplex."; sw = rw; hw = r; } ACT_DUPLEX_HALF[11:11];
        field { desc = "Blink while frames are sent."; sw = rw; hw = r; } ACT_TX_BLINK[10:10];
        field { desc = "Blink while frames are received."; sw = rw; hw = r; } ACT_RX_BLINK[9:9];
        field { desc = "On while frames are sent."; sw = rw; hw = r; } ACT_TX[8:8];
        field { desc = "On while frames are received."; sw = rw; hw = r; } ACT_RX[7:7];
        field { desc = "On while the link is up at 1000 Mbit/s."; sw = rw; hw = r; } ACT_1000M[6:6];
        field { desc = "On while the link is up at 100 Mbit/s."; sw = rw; hw = r; } ACT_100M[5:5];
        field { desc = "On while the link is up at 10 Mbit/s."; sw = rw; hw = r; } ACT_10M[4:4];
        field { desc = "Blink on collisions."; sw = rw; hw = r; } ACT_COLLISION_BLINK[3:3];
        field { desc = "Blink on activity at 1000 Mbit/s."; sw = rw; hw = r; } ACT_1000M_BLINK[2:2];
        field { desc = "Blink on activity at 100 Mbit/s."; sw = rw; hw = r; } ACT_100M_BLINK[1:1];
        field { desc = "Blink on activity at 10 Mbit/s."; sw = rw; hw = r; } ACT_10M_BLINK[0:0];
    } LED0_PORT[10] @ 0xD0004 += 0x4;

    reg {
        name = "LED group 1 behaviour and blink timing";
        desc = "Conditions that light or blink LED 1 of one port, plus the blink timing shared by all three LEDs of the port. Index: port = 0 to 9.";
        enum led1_port_blink_duty_e {
            V1_2 = 0 { desc = "On for 1/2 of the cycle"; };
            V2_3 = 1 { desc = "On for 2/3 of the cycle"; };
            V3_4 = 2 { desc = "On for 3/4 of the cycle"; };
            V5_6 = 3 { desc = "On for 5/6 of the cycle"; };
        };
        field { desc = "Alternative blink cycle. The cycle is 512 ms shifted right by the field value. An LED uses it when its LED2_PORT.FORCE_BLINK field is 3."; sw = rw; hw = r; } OTHER_BLINK[31:30];
        field { desc = "Blink cycle of the low power idle indication. The cycle is 512 ms shifted right by the field value."; sw = rw; hw = r; } EEE_BLINK[29:28];
        field { desc = "Swaps the on and off parts of the blink cycle. LED1_PORT.BLINK_DUTY then gives the off fraction."; sw = rw; hw = r; } BLINK_DUTY_COMP[27:27];
        field { desc = "Fraction of the blink cycle the LED is on."; sw = rw; hw = r; encode = led1_port_blink_duty_e; } BLINK_DUTY[26:25];
        field { desc = "Blink while the port is in low power idle."; sw = rw; hw = r; } ACT_EEE_BLINK[15:15];
        field { desc = "Blink when a loop is detected on the port."; sw = rw; hw = r; } ACT_LOOPDETECT_BLINK[14:14];
        field { desc = "Blink on any activity."; sw = rw; hw = r; } ACT_ACTIVE_BLINK[13:13];
        field { desc = "On while the link is up in full duplex."; sw = rw; hw = r; } ACT_DUPLEX_FULL[12:12];
        field { desc = "On while the link is up in half duplex."; sw = rw; hw = r; } ACT_DUPLEX_HALF[11:11];
        field { desc = "Blink while frames are sent."; sw = rw; hw = r; } ACT_TX_BLINK[10:10];
        field { desc = "Blink while frames are received."; sw = rw; hw = r; } ACT_RX_BLINK[9:9];
        field { desc = "On while frames are sent."; sw = rw; hw = r; } ACT_TX[8:8];
        field { desc = "On while frames are received."; sw = rw; hw = r; } ACT_RX[7:7];
        field { desc = "On while the link is up at 1000 Mbit/s."; sw = rw; hw = r; } ACT_1000M[6:6];
        field { desc = "On while the link is up at 100 Mbit/s."; sw = rw; hw = r; } ACT_100M[5:5];
        field { desc = "On while the link is up at 10 Mbit/s."; sw = rw; hw = r; } ACT_10M[4:4];
        field { desc = "Blink on collisions."; sw = rw; hw = r; } ACT_COLLISION_BLINK[3:3];
        field { desc = "Blink on activity at 1000 Mbit/s."; sw = rw; hw = r; } ACT_1000M_BLINK[2:2];
        field { desc = "Blink on activity at 100 Mbit/s."; sw = rw; hw = r; } ACT_100M_BLINK[1:1];
        field { desc = "Blink on activity at 10 Mbit/s."; sw = rw; hw = r; } ACT_10M_BLINK[0:0];
    } LED1_PORT[10] @ 0xD0040 += 0x4;

    reg {
        name = "LED group 2 behaviour and forced states";
        desc = "Conditions that light or blink LED 2 of one port, plus the forced state of all three LEDs of the port. Index: port = 0 to 9.";
        enum led2_port_force_e {
            DONTCARE = 0 { desc = "Not forced. The LED follows its behaviour bits"; };
            BLINK = 1 { desc = "Blink at the rate in LED2_PORT.FORCE_BLINK"; };
            ON = 2 { desc = "On"; };
            OFF = 3 { desc = "Off"; };
        };
        enum led2_port_force_blink_e {
            OTHER = 3 { desc = "Use the cycle in LED1_PORT.OTHER_BLINK"; };
        };
        field { desc = "Forced state of LED group grp of this port."; sw = rw; hw = r; encode = led2_port_force_e; } FORCE_2[27:26];
        field { desc = "Forced state of LED group grp of this port."; sw = rw; hw = r; encode = led2_port_force_e; } FORCE_1[23:22];
        field { desc = "Forced state of LED group grp of this port."; sw = rw; hw = r; encode = led2_port_force_e; } FORCE_0[19:18];
        field { desc = "Blink cycle of an LED that is forced to blink. The cycle is 512 ms shifted left by the field value."; sw = rw; hw = r; encode = led2_port_force_blink_e; } FORCE_BLINK_2[25:24];
        field { desc = "Blink cycle of an LED that is forced to blink. The cycle is 512 ms shifted left by the field value."; sw = rw; hw = r; encode = led2_port_force_blink_e; } FORCE_BLINK_1[21:20];
        field { desc = "Blink cycle of an LED that is forced to blink. The cycle is 512 ms shifted left by the field value."; sw = rw; hw = r; encode = led2_port_force_blink_e; } FORCE_BLINK_0[17:16];
        field { desc = "Blink while the port is in low power idle."; sw = rw; hw = r; } ACT_EEE_BLINK[15:15];
        field { desc = "Blink when a loop is detected on the port."; sw = rw; hw = r; } ACT_LOOPDETECT_BLINK[14:14];
        field { desc = "Blink on any activity."; sw = rw; hw = r; } ACT_ACTIVE_BLINK[13:13];
        field { desc = "On while the link is up in full duplex."; sw = rw; hw = r; } ACT_DUPLEX_FULL[12:12];
        field { desc = "On while the link is up in half duplex."; sw = rw; hw = r; } ACT_DUPLEX_HALF[11:11];
        field { desc = "Blink while frames are sent."; sw = rw; hw = r; } ACT_TX_BLINK[10:10];
        field { desc = "Blink while frames are received."; sw = rw; hw = r; } ACT_RX_BLINK[9:9];
        field { desc = "On while frames are sent."; sw = rw; hw = r; } ACT_TX[8:8];
        field { desc = "On while frames are received."; sw = rw; hw = r; } ACT_RX[7:7];
        field { desc = "On while the link is up at 1000 Mbit/s."; sw = rw; hw = r; } ACT_1000M[6:6];
        field { desc = "On while the link is up at 100 Mbit/s."; sw = rw; hw = r; } ACT_100M[5:5];
        field { desc = "On while the link is up at 10 Mbit/s."; sw = rw; hw = r; } ACT_10M[4:4];
        field { desc = "Blink on collisions."; sw = rw; hw = r; } ACT_COLLISION_BLINK[3:3];
        field { desc = "Blink on activity at 1000 Mbit/s."; sw = rw; hw = r; } ACT_1000M_BLINK[2:2];
        field { desc = "Blink on activity at 100 Mbit/s."; sw = rw; hw = r; } ACT_100M_BLINK[1:1];
        field { desc = "Blink on activity at 10 Mbit/s."; sw = rw; hw = r; } ACT_10M_BLINK[0:0];
    } LED2_PORT[10] @ 0xD0080 += 0x4;

    reg {
        name = "Serial LED control";
        desc = "Settings of the serial LED output.";
        field { desc = "The vendor SDK function fal_tiger_led_serial_enable_set() sets both bits to turn the serial LED output on and clears both to turn it off. The comment on the field in the Linux driver reads \"delay?\"."; sw = rw; hw = r; } UNK[25:24];
        field { desc = "Serial LED data is active low."; sw = rw; hw = r; } ACTIVE_LOW[4:4];
        field { desc = "Number of LED groups shifted out per port minus one."; sw = rw; hw = r; } GRP_NUM[1:0];
    } LED_SER_CTRL @ 0xD0100;

    reg {
        name = "Serial LED position map";
        desc = "Chooses which LED is shifted out at each position of the serial stream. One register holds five positions; index half is 0 for ports 0 to 4 and 1 for ports 5 to 9. Index: grp = 0 to 2, half = 0 to 1.";
        field { desc = "Port whose LED is shown at position slot."; sw = rw; hw = r; } DST_PORT_4[29:26];
        field { desc = "Port whose LED is shown at position slot."; sw = rw; hw = r; } DST_PORT_3[23:20];
        field { desc = "Port whose LED is shown at position slot."; sw = rw; hw = r; } DST_PORT_2[17:14];
        field { desc = "Port whose LED is shown at position slot."; sw = rw; hw = r; } DST_PORT_1[11:8];
        field { desc = "Port whose LED is shown at position slot."; sw = rw; hw = r; } DST_PORT_0[5:2];
        field { desc = "LED group shown at position slot."; sw = rw; hw = r; } DST_LED_4[25:24];
        field { desc = "LED group shown at position slot."; sw = rw; hw = r; } DST_LED_3[19:18];
        field { desc = "LED group shown at position slot."; sw = rw; hw = r; } DST_LED_2[13:12];
        field { desc = "LED group shown at position slot."; sw = rw; hw = r; } DST_LED_1[7:6];
        field { desc = "LED group shown at position slot."; sw = rw; hw = r; } DST_LED_0[1:0];
    } LED_SER_MAP[6] @ 0xD0104 += 0x4;

    reg {
        name = "Parallel LED port enable";
        desc = "Parallel LED outputs in use. The Linux driver defines the address only.";
        field { desc = "The vendor SDK function fal_tiger_led_parallel_output_set() writes a port mask to bits 9 to 0, one bit per port, under the comment \"select output port mask of parallel LED\". Bits 31 to 10 are not known."; sw = rw; hw = r; } VALUE[31:0];
    } LED_PAR_PORTS @ 0xD01C4;

    reg {
        name = "Parallel LED polarity";
        desc = "Inverts individual parallel LED outputs. With the bit clear the pin is low while the LED is on, which suits an LED wired active low; set the bit for an LED wired active high.";
        field { desc = "Inverts the output of one LED group of one port. The bit number is 10 × grp + port."; sw = rw; hw = r; } INV_2_9[29:29];
        field { desc = "Inverts the output of one LED group of one port. The bit number is 10 × grp + port."; sw = rw; hw = r; } INV_2_8[28:28];
        field { desc = "Inverts the output of one LED group of one port. The bit number is 10 × grp + port."; sw = rw; hw = r; } INV_2_7[27:27];
        field { desc = "Inverts the output of one LED group of one port. The bit number is 10 × grp + port."; sw = rw; hw = r; } INV_2_6[26:26];
        field { desc = "Inverts the output of one LED group of one port. The bit number is 10 × grp + port."; sw = rw; hw = r; } INV_2_5[25:25];
        field { desc = "Inverts the output of one LED group of one port. The bit number is 10 × grp + port."; sw = rw; hw = r; } INV_2_4[24:24];
        field { desc = "Inverts the output of one LED group of one port. The bit number is 10 × grp + port."; sw = rw; hw = r; } INV_2_3[23:23];
        field { desc = "Inverts the output of one LED group of one port. The bit number is 10 × grp + port."; sw = rw; hw = r; } INV_2_2[22:22];
        field { desc = "Inverts the output of one LED group of one port. The bit number is 10 × grp + port."; sw = rw; hw = r; } INV_2_1[21:21];
        field { desc = "Inverts the output of one LED group of one port. The bit number is 10 × grp + port."; sw = rw; hw = r; } INV_2_0[20:20];
        field { desc = "Inverts the output of one LED group of one port. The bit number is 10 × grp + port."; sw = rw; hw = r; } INV_1_9[19:19];
        field { desc = "Inverts the output of one LED group of one port. The bit number is 10 × grp + port."; sw = rw; hw = r; } INV_1_8[18:18];
        field { desc = "Inverts the output of one LED group of one port. The bit number is 10 × grp + port."; sw = rw; hw = r; } INV_1_7[17:17];
        field { desc = "Inverts the output of one LED group of one port. The bit number is 10 × grp + port."; sw = rw; hw = r; } INV_1_6[16:16];
        field { desc = "Inverts the output of one LED group of one port. The bit number is 10 × grp + port."; sw = rw; hw = r; } INV_1_5[15:15];
        field { desc = "Inverts the output of one LED group of one port. The bit number is 10 × grp + port."; sw = rw; hw = r; } INV_1_4[14:14];
        field { desc = "Inverts the output of one LED group of one port. The bit number is 10 × grp + port."; sw = rw; hw = r; } INV_1_3[13:13];
        field { desc = "Inverts the output of one LED group of one port. The bit number is 10 × grp + port."; sw = rw; hw = r; } INV_1_2[12:12];
        field { desc = "Inverts the output of one LED group of one port. The bit number is 10 × grp + port."; sw = rw; hw = r; } INV_1_1[11:11];
        field { desc = "Inverts the output of one LED group of one port. The bit number is 10 × grp + port."; sw = rw; hw = r; } INV_1_0[10:10];
        field { desc = "Inverts the output of one LED group of one port. The bit number is 10 × grp + port."; sw = rw; hw = r; } INV_0_9[9:9];
        field { desc = "Inverts the output of one LED group of one port. The bit number is 10 × grp + port."; sw = rw; hw = r; } INV_0_8[8:8];
        field { desc = "Inverts the output of one LED group of one port. The bit number is 10 × grp + port."; sw = rw; hw = r; } INV_0_7[7:7];
        field { desc = "Inverts the output of one LED group of one port. The bit number is 10 × grp + port."; sw = rw; hw = r; } INV_0_6[6:6];
        field { desc = "Inverts the output of one LED group of one port. The bit number is 10 × grp + port."; sw = rw; hw = r; } INV_0_5[5:5];
        field { desc = "Inverts the output of one LED group of one port. The bit number is 10 × grp + port."; sw = rw; hw = r; } INV_0_4[4:4];
        field { desc = "Inverts the output of one LED group of one port. The bit number is 10 × grp + port."; sw = rw; hw = r; } INV_0_3[3:3];
        field { desc = "Inverts the output of one LED group of one port. The bit number is 10 × grp + port."; sw = rw; hw = r; } INV_0_2[2:2];
        field { desc = "Inverts the output of one LED group of one port. The bit number is 10 × grp + port."; sw = rw; hw = r; } INV_0_1[1:1];
        field { desc = "Inverts the output of one LED group of one port. The bit number is 10 × grp + port."; sw = rw; hw = r; } INV_0_0[0:0];
    } LED_PAR_INV @ 0xD01C8;

    reg {
        name = "Parallel LED pin map";
        desc = "Chooses which LED each parallel LED pin of one port position shows. Index: port = 0 to 9.";
        field { desc = "Port whose LED is shown on pin group grp."; sw = rw; hw = r; } DST_PORT_2[17:14];
        field { desc = "Port whose LED is shown on pin group grp."; sw = rw; hw = r; } DST_PORT_1[11:8];
        field { desc = "Port whose LED is shown on pin group grp."; sw = rw; hw = r; } DST_PORT_0[5:2];
        field { desc = "LED group shown on pin group grp."; sw = rw; hw = r; } DST_LED_2[13:12];
        field { desc = "LED group shown on pin group grp."; sw = rw; hw = r; } DST_LED_1[7:6];
        field { desc = "LED group shown on pin group grp."; sw = rw; hw = r; } DST_LED_0[1:0];
    } LED_PAR_MAP[10] @ 0xD01D0 += 0x4;

    reg {
        name = "Configuration byte store command";
        desc = "Command register of the configuration byte store of 256 bytes. Writing it starts the command; Identify the part shows the read sequence.";
        enum edata_ctrl_op_e {
            READ = 5 { desc = "Read the byte at EDATA_CTRL.ADDR into EDATA_DATA.DATA"; };
        };
        field { desc = "Byte address from 0 to 255."; sw = rw; hw = r; } ADDR[15:8];
        field { desc = "Command."; sw = rw; hw = r; encode = edata_ctrl_op_e; } OP[3:0];
    } EDATA_CTRL @ 0xE0000;

    reg {
        name = "Configuration byte store data and status";
        desc = "Result and state of the last EDATA_CTRL command.";
        enum edata_data_status_e {
            IDLE = 3 { desc = "No command is running. EDATA_DATA.DATA is valid"; };
        };
        field { desc = "Byte that was read."; sw = r; hw = w; } DATA[31:24];
        field { desc = "State of the store."; sw = r; hw = w; encode = edata_data_status_e; } STATUS[3:0];
    } EDATA_DATA @ 0xE0004;

    reg {
        name = "System clock select";
        desc = "Shows which core clock the switch runs from. yt921x_chip_detect reads it. The time slots of METER_SLOT and PORT_SHAPE_SLOT count in units of eight core clock periods.";
        enum sys_clk_sel_e {
            V125M = 0 { desc = "125 MHz core clock"; };
            V143M = 1 { desc = "143 MHz core clock"; };
        };
        field { desc = "Core clock in use. Value 0 stands for 125 MHz in the YT9215 family and 167 MHz in the YT9218 family. The core clock table lists the clock periods."; sw = rw; hw = r; encode = sys_clk_sel_e; } SEL[1:0];
    } SYS_CLK @ 0xE0040;

    reg {
        name = "Internal MDIO master start";
        desc = "Starts a transfer on the internal MDIO master and shows when it has finished; see MDIO master transfer.";
        field { desc = "Write 1 to start the transfer set up in INT_MBUS_CTRL. Reads 1 until the transfer is complete."; sw = rw; hw = r; } START[0:0];
    } INT_MBUS_OP @ 0xF0000;

    reg {
        name = "Internal MDIO master command";
        desc = "Address and direction of the next transfer to a built-in PHY or SerDes PCS.";
        enum int_mbus_ctrl_type_e {
            C22 = 4 { desc = "IEEE 802.3 clause 22 frame"; };
        };
        enum int_mbus_ctrl_op_e {
            WRITE = 1 { desc = "Write the register"; };
            READ = 2 { desc = "Read the register"; };
        };
        field { desc = "PHY address from 0 to 31. On the internal bus it equals the port number."; sw = rw; hw = r; } PORT[25:21];
        field { desc = "PHY register number from 0 to 31."; sw = rw; hw = r; } REG[20:16];
        field { desc = "Frame format. The comment on the field reads \"wild guess\", so the width of the field is inferred."; sw = rw; hw = r; encode = int_mbus_ctrl_type_e; } TYPE[11:8];
        field { desc = "Direction. The comment on the field reads \"wild guess\", so the width of the field is inferred."; sw = rw; hw = r; encode = int_mbus_ctrl_op_e; } OP[3:2];
    } INT_MBUS_CTRL @ 0xF0004;

    reg {
        name = "Internal MDIO master write data";
        desc = "Data for the next write transfer on the internal MDIO master.";
        field { desc = "The 16-bit PHY register value."; sw = rw; hw = r; } DATA[15:0];
    } INT_MBUS_DOUT @ 0xF0008;

    reg {
        name = "Internal MDIO master read data";
        desc = "Data returned by the last read transfer on the internal MDIO master.";
        field { desc = "The 16-bit PHY register value."; sw = r; hw = w; } DATA[15:0];
    } INT_MBUS_DIN @ 0xF000C;

    reg {
        name = "Port egress tag protocol select";
        desc = "Chooses which TPID_EGR entry a port writes into the VLAN tags it adds on transmit. Index: port = 0 to 10.";
        field { desc = "Index of the TPID_EGR entry used for customer tags."; sw = rw; hw = r; } TPID_CTAG[5:4];
        field { desc = "Index of the TPID_EGR entry used for service tags."; sw = rw; hw = r; } TPID_STAG[3:2];
    } PORT_EGR[11] @ 0x100000 += 0x4;

    reg {
        name = "Egress tag protocol identifiers";
        desc = "Four tag protocol identifier values a port can write into transmitted VLAN tags. Index: n = 0 to 3.";
        field { desc = "Tag protocol identifier. An example is 0x8100."; sw = rw; hw = r; } TPID[15:0];
    } TPID_EGR[4] @ 0x100300 += 0x4;

    reg {
        name = "DSCP to internal priority map";
        desc = "Internal priority and colour for each of the 64 IP DSCP values. Index: dscp = 0 to 63.";
        enum ipm_dscp_color_e {
            GREEN = 0 { desc = "Lowest drop precedence"; };
            YELLOW = 1 { desc = "Yellow"; };
            RED = 2 { desc = "Highest drop precedence"; };
        };
        field { desc = "Internal priority from 0 to 7."; sw = rw; hw = r; } PRIO[4:2];
        field { desc = "Drop precedence colour. It is inferred from METER_CTRL.COLOR_BLIND that the meters use it."; sw = rw; hw = r; encode = ipm_dscp_color_e; } COLOR[1:0];
    } IPM_DSCP[64] @ 0x180000 += 0x4;

    reg {
        name = "VLAN priority to internal priority map";
        desc = "Internal priority and colour for each VLAN tag priority. There are two maps (index map); each has one entry per drop eligible bit value (dei) and priority code point (pcp). The vendor SDK functions fal_tiger_qos_intPri_cpri_map_set() and fal_tiger_qos_intPri_spri_map_set() write a fixed map number to PORT_QOS and use it as the index map: 0 for the customer tag and 1 for the service tag. Index: map = 0 to 1, dei = 0 to 1, pcp = 0 to 7.";
        enum ipm_pcp_color_e {
            GREEN = 0 { desc = "Lowest drop precedence"; };
            YELLOW = 1 { desc = "Yellow"; };
            RED = 2 { desc = "Highest drop precedence"; };
        };
        field { desc = "Internal priority from 0 to 7."; sw = rw; hw = r; } PRIO[4:2];
        field { desc = "Drop precedence colour. It is inferred from METER_CTRL.COLOR_BLIND that the meters use it."; sw = rw; hw = r; encode = ipm_pcp_color_e; } COLOR[1:0];
    } IPM_PCP[2][2][8] @ 0x180100 += 0x4;

    reg {
        name = "Port priority";
        desc = "Port default priority and, by the code of the vendor SDK that the description of IPM_PCP names, the choice of IPM_PCP map. Index: port = 0 to 10.";
        field { desc = "Index map of the IPM_PCP map used for customer tags."; sw = rw; hw = r; } CVLAN_PRIO_MAP_ID[5:5];
        field { desc = "Index map of the IPM_PCP map used for service tags."; sw = rw; hw = r; } SVLAN_PRIO_MAP_ID[4:4];
        field { desc = "Port default priority from 0 to 7."; sw = rw; hw = r; } PRIO[3:1];
        field { desc = "Enables the port default priority."; sw = rw; hw = r; } PRIO_EN[0:0];
    } PORT_QOS[11] @ 0x180180 += 0x4;

    reg {
        name = "Port priority source order";
        desc = "Ranks the sources of a frame's internal priority on one port. Each source has a 3-bit weight. It is inferred that the source with the highest non-zero weight that applies to the frame wins; a comment in yt_qos.h of the vendor SDK reads \"The higher the value, the higher the priority\". Priority sources lists the source numbers. Index: port = 0 to 10.";
        field { desc = "Weight of priority source app. 0 disables the source, except for the port default priority which is enabled by PORT_QOS.PRIO_EN."; sw = rw; hw = r; } APP_7[23:21];
        field { desc = "Weight of priority source app. 0 disables the source, except for the port default priority which is enabled by PORT_QOS.PRIO_EN."; sw = rw; hw = r; } APP_6[20:18];
        field { desc = "Weight of priority source app. 0 disables the source, except for the port default priority which is enabled by PORT_QOS.PRIO_EN."; sw = rw; hw = r; } APP_5[17:15];
        field { desc = "Weight of priority source app. 0 disables the source, except for the port default priority which is enabled by PORT_QOS.PRIO_EN."; sw = rw; hw = r; } APP_4[14:12];
        field { desc = "Weight of priority source app. 0 disables the source, except for the port default priority which is enabled by PORT_QOS.PRIO_EN."; sw = rw; hw = r; } APP_3[11:9];
        field { desc = "Weight of priority source app. 0 disables the source, except for the port default priority which is enabled by PORT_QOS.PRIO_EN."; sw = rw; hw = r; } APP_2[8:6];
        field { desc = "Weight of priority source app. 0 disables the source, except for the port default priority which is enabled by PORT_QOS.PRIO_EN."; sw = rw; hw = r; } APP_1[5:3];
        field { desc = "Weight of priority source app. 0 disables the source, except for the port default priority which is enabled by PORT_QOS.PRIO_EN."; sw = rw; hw = r; } APP_0[2:0];
    } PORT_PRIO_ORD[11] @ 0x180200 += 0x4;

    reg {
        name = "Ingress VLAN filter";
        desc = "Per-port ingress VLAN membership check.";
        field { desc = "IGMP frames received on port port skip the ingress membership check."; sw = rw; hw = r; } PORT_BYPASS_IGMP_10[21:21];
        field { desc = "IGMP frames received on port port skip the ingress membership check."; sw = rw; hw = r; } PORT_BYPASS_IGMP_9[20:20];
        field { desc = "IGMP frames received on port port skip the ingress membership check."; sw = rw; hw = r; } PORT_BYPASS_IGMP_8[19:19];
        field { desc = "IGMP frames received on port port skip the ingress membership check."; sw = rw; hw = r; } PORT_BYPASS_IGMP_7[18:18];
        field { desc = "IGMP frames received on port port skip the ingress membership check."; sw = rw; hw = r; } PORT_BYPASS_IGMP_6[17:17];
        field { desc = "IGMP frames received on port port skip the ingress membership check."; sw = rw; hw = r; } PORT_BYPASS_IGMP_5[16:16];
        field { desc = "IGMP frames received on port port skip the ingress membership check."; sw = rw; hw = r; } PORT_BYPASS_IGMP_4[15:15];
        field { desc = "IGMP frames received on port port skip the ingress membership check."; sw = rw; hw = r; } PORT_BYPASS_IGMP_3[14:14];
        field { desc = "IGMP frames received on port port skip the ingress membership check."; sw = rw; hw = r; } PORT_BYPASS_IGMP_2[13:13];
        field { desc = "IGMP frames received on port port skip the ingress membership check."; sw = rw; hw = r; } PORT_BYPASS_IGMP_1[12:12];
        field { desc = "IGMP frames received on port port skip the ingress membership check."; sw = rw; hw = r; } PORT_BYPASS_IGMP_0[11:11];
        field { desc = "Port port receives frames only of VLANs that list it."; sw = rw; hw = r; } PORT_10[10:10];
        field { desc = "Port port receives frames only of VLANs that list it."; sw = rw; hw = r; } PORT_9[9:9];
        field { desc = "Port port receives frames only of VLANs that list it."; sw = rw; hw = r; } PORT_8[8:8];
        field { desc = "Port port receives frames only of VLANs that list it."; sw = rw; hw = r; } PORT_7[7:7];
        field { desc = "Port port receives frames only of VLANs that list it."; sw = rw; hw = r; } PORT_6[6:6];
        field { desc = "Port port receives frames only of VLANs that list it."; sw = rw; hw = r; } PORT_5[5:5];
        field { desc = "Port port receives frames only of VLANs that list it."; sw = rw; hw = r; } PORT_4[4:4];
        field { desc = "Port port receives frames only of VLANs that list it."; sw = rw; hw = r; } PORT_3[3:3];
        field { desc = "Port port receives frames only of VLANs that list it."; sw = rw; hw = r; } PORT_2[2:2];
        field { desc = "Port port receives frames only of VLANs that list it."; sw = rw; hw = r; } PORT_1[1:1];
        field { desc = "Port port receives frames only of VLANs that list it."; sw = rw; hw = r; } PORT_0[0:0];
    } VLAN_IGR_FILTER @ 0x180280;

    reg {
        name = "Port isolation";
        desc = "Destination ports that frames received on one port must not be sent to. This is the mechanism that separates ports into groups; see Port isolation. Index: port = 0 to 10.";
        field { desc = "Frames received on this port are never sent to port port."; sw = rw; hw = r; } BLOCK_10[10:10];
        field { desc = "Frames received on this port are never sent to port port."; sw = rw; hw = r; } BLOCK_9[9:9];
        field { desc = "Frames received on this port are never sent to port port."; sw = rw; hw = r; } BLOCK_8[8:8];
        field { desc = "Frames received on this port are never sent to port port."; sw = rw; hw = r; } BLOCK_7[7:7];
        field { desc = "Frames received on this port are never sent to port port."; sw = rw; hw = r; } BLOCK_6[6:6];
        field { desc = "Frames received on this port are never sent to port port."; sw = rw; hw = r; } BLOCK_5[5:5];
        field { desc = "Frames received on this port are never sent to port port."; sw = rw; hw = r; } BLOCK_4[4:4];
        field { desc = "Frames received on this port are never sent to port port."; sw = rw; hw = r; } BLOCK_3[3:3];
        field { desc = "Frames received on this port are never sent to port port."; sw = rw; hw = r; } BLOCK_2[2:2];
        field { desc = "Frames received on this port are never sent to port port."; sw = rw; hw = r; } BLOCK_1[1:1];
        field { desc = "Frames received on this port are never sent to port port."; sw = rw; hw = r; } BLOCK_0[0:0];
    } PORT_ISOLATION[11] @ 0x180294 += 0x4;

    reg {
        name = "Spanning tree port states";
        desc = "Port states of one spanning tree instance, two bits per port. A VLAN chooses its instance with VLAN_CTRL.STP_ID. Index: inst = 0 to 15.";
        enum stp_port_e {
            DISABLED = 0 { desc = "Port neither forwards nor learns"; };
            LEARNING = 1 { desc = "Port learns addresses but does not forward"; };
            BLOCKING = 2 { desc = "Port neither forwards nor learns. It is inferred from IEEE 802.1D that the port receives bridge protocol frames"; };
            FORWARD = 3 { desc = "Port forwards and learns"; };
        };
        field { desc = "State of port port in this instance."; sw = rw; hw = r; encode = stp_port_e; } PORT_10[21:20];
        field { desc = "State of port port in this instance."; sw = rw; hw = r; encode = stp_port_e; } PORT_9[19:18];
        field { desc = "State of port port in this instance."; sw = rw; hw = r; encode = stp_port_e; } PORT_8[17:16];
        field { desc = "State of port port in this instance."; sw = rw; hw = r; encode = stp_port_e; } PORT_7[15:14];
        field { desc = "State of port port in this instance."; sw = rw; hw = r; encode = stp_port_e; } PORT_6[13:12];
        field { desc = "State of port port in this instance."; sw = rw; hw = r; encode = stp_port_e; } PORT_5[11:10];
        field { desc = "State of port port in this instance."; sw = rw; hw = r; encode = stp_port_e; } PORT_4[9:8];
        field { desc = "State of port port in this instance."; sw = rw; hw = r; encode = stp_port_e; } PORT_3[7:6];
        field { desc = "State of port port in this instance."; sw = rw; hw = r; encode = stp_port_e; } PORT_2[5:4];
        field { desc = "State of port port in this instance."; sw = rw; hw = r; encode = stp_port_e; } PORT_1[3:2];
        field { desc = "State of port port in this instance."; sw = rw; hw = r; encode = stp_port_e; } PORT_0[1:0];
    } STP[16] @ 0x18038C += 0x4;

    reg {
        name = "Port address learning";
        desc = "Controls learning of source addresses on one port. Index: port = 0 to 10.";
        enum port_learn_mode_e {
            AUTO = 0 { desc = "The switch learns by itself"; };
            AUTO_AND_COPY = 1 { desc = "The switch learns and copies the frame to the CPU"; };
            CPU_CONTROL = 2 { desc = "Only the CPU adds entries"; };
        };
        field { desc = "Function not known."; sw = rw; hw = r; } VID_LEARN_MULTI_EN[22:22];
        field { desc = "Function not known."; sw = rw; hw = r; } VID_LEARN_MODE[21:21];
        field { desc = "Function not known."; sw = rw; hw = r; } VID_LEARN_EN[20:20];
        field { desc = "Copy frames with a not yet learned source address to the CPU."; sw = rw; hw = r; } SUSPEND_COPY_EN[19:19];
        field { desc = "Drop frames with a not yet learned source address."; sw = rw; hw = r; } SUSPEND_DROP_EN[18:18];
        field { desc = "Disables address learning on the port."; sw = rw; hw = r; } DIS[17:17];
        field { desc = "Enables the limit in PORT_LEARN.LIMIT."; sw = rw; hw = r; } LIMIT_EN[16:16];
        field { desc = "Largest number of addresses learned on the port. The vendor SDK lists this field as 13 bits wide, at bits 15 to 3."; sw = rw; hw = r; } LIMIT[15:8];
        field { desc = "Drop frames with a new source address once the limit is reached."; sw = rw; hw = r; } DROP_ON_EXCEEDED[2:2];
        field { desc = "Who learns addresses."; sw = rw; hw = r; encode = port_learn_mode_e; } MODE[1:0];
    } PORT_LEARN[11] @ 0x1803D0 += 0x4;

    reg {
        name = "Address ageing interval";
        desc = "Time base of forwarding database ageing.";
        field { desc = "Ageing time in units of 5 seconds."; sw = rw; hw = r; } INTERVAL[15:0];
    } AGEING @ 0x180440;

    reg {
        name = "Forwarding database command data 0";
        desc = "First input word of a forwarding database command; see Forwarding database.";
        field { desc = "MAC address bytes 0 to 3. Byte 0 is in bits 31 to 24."; sw = rw; hw = r; } ADDR_HI4[31:0];
    } FDB_IN0 @ 0x180454;

    reg {
        name = "Forwarding database command data 1";
        desc = "Second input word of a forwarding database command.";
        enum fdb_in1_status_e {
            INVALID = 0 { desc = "Entry is empty"; };
            MIN_TIME = 1 { desc = "Dynamic entry about to age out"; };
            MOVE_AGING_MAX_TIME = 3 { desc = "Dynamic entry that moved to another port"; };
            MAX_TIME = 5 { desc = "Dynamic entry just learned or refreshed"; };
            PENDING = 6 { desc = "Entry waiting for the CPU to confirm it"; };
            STATIC = 7 { desc = "Static entry that never ages out"; };
        };
        field { desc = "Apply the priority of the entry to frames sent to this address."; sw = rw; hw = r; } EGR_PRIO_EN[31:31];
        field { desc = "State of the entry."; sw = rw; hw = r; encode = fdb_in1_status_e; } STATUS[30:28];
        field { desc = "Filtering ID of the entry. The Linux driver uses the VLAN ID as the filtering ID."; sw = rw; hw = r; } FID[27:16];
        field { desc = "MAC address bytes 4 and 5. Byte 4 is in bits 15 to 8."; sw = rw; hw = r; } ADDR_LO2[15:0];
    } FDB_IN1 @ 0x180458;

    reg {
        name = "Forwarding database command data 2";
        desc = "Third input word of a forwarding database command.";
        field { desc = "Ageing state of an entry that moved between ports."; sw = rw; hw = r; } MOVE_AGING_STATUS[31:30];
        field { desc = "Drop frames received from this address."; sw = rw; hw = r; } IGR_DROP[29:29];
        field { desc = "Ports that frames to this address are sent to. Each port has one bit."; sw = rw; hw = r; } EGR_PORTS[28:18];
        field { desc = "Drop frames sent to this address."; sw = rw; hw = r; } EGR_DROP[17:17];
        field { desc = "Also copy frames to this address to the CPU."; sw = rw; hw = r; } COPY_TO_CPU[16:16];
        field { desc = "Apply FDB_IN2.PRIO to frames received from this address."; sw = rw; hw = r; } IGR_PRIO_EN[15:15];
        field { desc = "Priority given by this entry. It is a source for PORT_PRIO_ORD."; sw = rw; hw = r; } PRIO[14:12];
        field { desc = "Replacement VLAN ID for frames matching the entry."; sw = rw; hw = r; } NEW_VID[11:0];
    } FDB_IN2 @ 0x18045C;

    reg {
        name = "Forwarding database command";
        desc = "Selects and starts a forwarding database command. Write the input words first, then this register with FDB_OP.START set, then wait for FDB_RESULT.DONE.";
        enum fdb_op_flush_e {
            ALL = 0 { desc = "Every entry of the kind that FDB_OP.FLUSH_MCAST selects"; };
            PORT = 1 { desc = "Entries of the ports in FDB_IN2.EGR_PORTS"; };
            PORT_VID = 2 { desc = "Entries of the ports in FDB_IN2.EGR_PORTS with the filtering ID in FDB_IN1.FID"; };
            VID = 3 { desc = "Entries with the filtering ID in FDB_IN1.FID"; };
        };
        enum fdb_op_next_type_e {
            UCAST_PORT = 0 { desc = "Unicast entries of one port"; };
            UCAST_VID = 1 { desc = "Unicast entries of one filtering ID"; };
            UCAST = 2 { desc = "All unicast entries"; };
            MCAST = 3 { desc = "Multicast entries"; };
        };
        enum fdb_op_op_e {
            ADD = 0 { desc = "Write an entry"; };
            DEL = 1 { desc = "Delete an entry"; };
            GET_ONE = 2 { desc = "Read one entry"; };
            GET_NEXT = 3 { desc = "Read the next used entry after FDB_OP.INDEX"; };
            FLUSH = 4 { desc = "Delete many entries"; };
        };
        field { desc = "Entry index from 0 to 4095. It is used when FDB_OP.MODE_INDEX is set."; sw = rw; hw = r; } INDEX[22:11];
        field { desc = "Addresses the entry by FDB_OP.INDEX. Value 0 addresses it by MAC address and filtering ID."; sw = rw; hw = r; } MODE_INDEX[10:10];
        field { desc = "A flush removes multicast entries in place of unicast entries. The vendor SDK list yt_l2_tbl_op_flush_mode_t gives this meaning to the bit."; sw = rw; hw = r; } FLUSH_MCAST[9:9];
        field { desc = "Scope of a flush."; sw = rw; hw = r; encode = fdb_op_flush_e; } FLUSH[8:7];
        field { desc = "A flush also removes static entries."; sw = rw; hw = r; } FLUSH_STATIC[6:6];
        field { desc = "Which entries FDB_OP.OP.GET_NEXT walks."; sw = rw; hw = r; encode = fdb_op_next_type_e; } NEXT_TYPE[5:4];
        field { desc = "Command."; sw = rw; hw = r; encode = fdb_op_op_e; } OP[3:1];
        field { desc = "Write 1 to start the command."; sw = rw; hw = r; } START[0:0];
    } FDB_OP @ 0x180460;

    reg {
        name = "Forwarding database command result";
        desc = "Completion flag and outcome of the last FDB_OP command.";
        field { desc = "1 when the command has finished."; sw = r; hw = w; } DONE[15:15];
        field { desc = "No entry matched."; sw = r; hw = w; } NOTFOUND[14:14];
        field { desc = "The command overwrote an existing entry."; sw = r; hw = w; } OVERWRITED[13:13];
        field { desc = "Index of the entry the command acted on."; sw = r; hw = w; } INDEX[11:0];
    } FDB_RESULT @ 0x180464;

    reg {
        name = "Forwarding database result data 0";
        desc = "First word of the entry read by a FDB_OP.OP.GET_ONE or FDB_OP.OP.GET_NEXT command.";
        field { desc = "MAC address bytes 0 to 3. Byte 0 is in bits 31 to 24."; sw = r; hw = w; } ADDR_HI4[31:0];
    } FDB_OUT0 @ 0x1804B0;

    reg {
        name = "Forwarding database result data 1";
        desc = "Second word of the entry read by a FDB_OP.OP.GET_ONE or FDB_OP.OP.GET_NEXT command.";
        enum fdb_out1_status_e {
            INVALID = 0 { desc = "Entry is empty"; };
            MIN_TIME = 1 { desc = "Dynamic entry about to age out"; };
            MOVE_AGING_MAX_TIME = 3 { desc = "Dynamic entry that moved to another port"; };
            MAX_TIME = 5 { desc = "Dynamic entry just learned or refreshed"; };
            PENDING = 6 { desc = "Entry waiting for the CPU to confirm it"; };
            STATIC = 7 { desc = "Static entry that never ages out"; };
        };
        field { desc = "Apply the priority of the entry to frames sent to this address."; sw = r; hw = w; } EGR_PRIO_EN[31:31];
        field { desc = "State of the entry."; sw = r; hw = w; encode = fdb_out1_status_e; } STATUS[30:28];
        field { desc = "Filtering ID of the entry. The Linux driver uses the VLAN ID as the filtering ID."; sw = r; hw = w; } FID[27:16];
        field { desc = "MAC address bytes 4 and 5. Byte 4 is in bits 15 to 8."; sw = r; hw = w; } ADDR_LO2[15:0];
    } FDB_OUT1 @ 0x1804B4;

    reg {
        name = "Forwarding database result data 2";
        desc = "Third word of the entry read by a FDB_OP.OP.GET_ONE or FDB_OP.OP.GET_NEXT command.";
        field { desc = "Ageing state of an entry that moved between ports."; sw = r; hw = w; } MOVE_AGING_STATUS[31:30];
        field { desc = "Drop frames received from this address."; sw = r; hw = w; } IGR_DROP[29:29];
        field { desc = "Ports that frames to this address are sent to. Each port has one bit."; sw = r; hw = w; } EGR_PORTS[28:18];
        field { desc = "Drop frames sent to this address."; sw = r; hw = w; } EGR_DROP[17:17];
        field { desc = "Also copy frames to this address to the CPU."; sw = r; hw = w; } COPY_TO_CPU[16:16];
        field { desc = "Apply FDB_OUT2.PRIO to frames received from this address."; sw = r; hw = w; } IGR_PRIO_EN[15:15];
        field { desc = "Priority given by this entry. It is a source for PORT_PRIO_ORD."; sw = r; hw = w; } PRIO[14:12];
        field { desc = "Replacement VLAN ID for frames matching the entry."; sw = r; hw = w; } NEW_VID[11:0];
    } FDB_OUT2 @ 0x1804B8;

    reg {
        name = "Unknown unicast flood filter";
        desc = "Port mask for flooded frames with an unknown unicast destination. yt921x_chip_setup_dsa sets the bit of every port.";
        field { desc = "It is inferred from the word \"filter\" in the register name that frames of this class are not flooded to port port while its bit is set."; sw = rw; hw = r; } PORTS_10[10:10];
        field { desc = "It is inferred from the word \"filter\" in the register name that frames of this class are not flooded to port port while its bit is set."; sw = rw; hw = r; } PORTS_9[9:9];
        field { desc = "It is inferred from the word \"filter\" in the register name that frames of this class are not flooded to port port while its bit is set."; sw = rw; hw = r; } PORTS_8[8:8];
        field { desc = "It is inferred from the word \"filter\" in the register name that frames of this class are not flooded to port port while its bit is set."; sw = rw; hw = r; } PORTS_7[7:7];
        field { desc = "It is inferred from the word \"filter\" in the register name that frames of this class are not flooded to port port while its bit is set."; sw = rw; hw = r; } PORTS_6[6:6];
        field { desc = "It is inferred from the word \"filter\" in the register name that frames of this class are not flooded to port port while its bit is set."; sw = rw; hw = r; } PORTS_5[5:5];
        field { desc = "It is inferred from the word \"filter\" in the register name that frames of this class are not flooded to port port while its bit is set."; sw = rw; hw = r; } PORTS_4[4:4];
        field { desc = "It is inferred from the word \"filter\" in the register name that frames of this class are not flooded to port port while its bit is set."; sw = rw; hw = r; } PORTS_3[3:3];
        field { desc = "It is inferred from the word \"filter\" in the register name that frames of this class are not flooded to port port while its bit is set."; sw = rw; hw = r; } PORTS_2[2:2];
        field { desc = "It is inferred from the word \"filter\" in the register name that frames of this class are not flooded to port port while its bit is set."; sw = rw; hw = r; } PORTS_1[1:1];
        field { desc = "It is inferred from the word \"filter\" in the register name that frames of this class are not flooded to port port while its bit is set."; sw = rw; hw = r; } PORTS_0[0:0];
    } FILTER_UNK_UCAST @ 0x180508;

    reg {
        name = "Unknown multicast flood filter";
        desc = "Port mask for flooded frames with an unknown multicast destination. yt921x_chip_setup_dsa sets the bit of every port.";
        field { desc = "It is inferred from the word \"filter\" in the register name that frames of this class are not flooded to port port while its bit is set."; sw = rw; hw = r; } PORTS_10[10:10];
        field { desc = "It is inferred from the word \"filter\" in the register name that frames of this class are not flooded to port port while its bit is set."; sw = rw; hw = r; } PORTS_9[9:9];
        field { desc = "It is inferred from the word \"filter\" in the register name that frames of this class are not flooded to port port while its bit is set."; sw = rw; hw = r; } PORTS_8[8:8];
        field { desc = "It is inferred from the word \"filter\" in the register name that frames of this class are not flooded to port port while its bit is set."; sw = rw; hw = r; } PORTS_7[7:7];
        field { desc = "It is inferred from the word \"filter\" in the register name that frames of this class are not flooded to port port while its bit is set."; sw = rw; hw = r; } PORTS_6[6:6];
        field { desc = "It is inferred from the word \"filter\" in the register name that frames of this class are not flooded to port port while its bit is set."; sw = rw; hw = r; } PORTS_5[5:5];
        field { desc = "It is inferred from the word \"filter\" in the register name that frames of this class are not flooded to port port while its bit is set."; sw = rw; hw = r; } PORTS_4[4:4];
        field { desc = "It is inferred from the word \"filter\" in the register name that frames of this class are not flooded to port port while its bit is set."; sw = rw; hw = r; } PORTS_3[3:3];
        field { desc = "It is inferred from the word \"filter\" in the register name that frames of this class are not flooded to port port while its bit is set."; sw = rw; hw = r; } PORTS_2[2:2];
        field { desc = "It is inferred from the word \"filter\" in the register name that frames of this class are not flooded to port port while its bit is set."; sw = rw; hw = r; } PORTS_1[1:1];
        field { desc = "It is inferred from the word \"filter\" in the register name that frames of this class are not flooded to port port while its bit is set."; sw = rw; hw = r; } PORTS_0[0:0];
    } FILTER_UNK_MCAST @ 0x18050C;

    reg {
        name = "Multicast flood filter";
        desc = "Ports that do not receive multicast frames.";
        field { desc = "It is inferred from the word \"filter\" in the register name that frames of this class are not flooded to port port while its bit is set."; sw = rw; hw = r; } PORTS_10[10:10];
        field { desc = "It is inferred from the word \"filter\" in the register name that frames of this class are not flooded to port port while its bit is set."; sw = rw; hw = r; } PORTS_9[9:9];
        field { desc = "It is inferred from the word \"filter\" in the register name that frames of this class are not flooded to port port while its bit is set."; sw = rw; hw = r; } PORTS_8[8:8];
        field { desc = "It is inferred from the word \"filter\" in the register name that frames of this class are not flooded to port port while its bit is set."; sw = rw; hw = r; } PORTS_7[7:7];
        field { desc = "It is inferred from the word \"filter\" in the register name that frames of this class are not flooded to port port while its bit is set."; sw = rw; hw = r; } PORTS_6[6:6];
        field { desc = "It is inferred from the word \"filter\" in the register name that frames of this class are not flooded to port port while its bit is set."; sw = rw; hw = r; } PORTS_5[5:5];
        field { desc = "It is inferred from the word \"filter\" in the register name that frames of this class are not flooded to port port while its bit is set."; sw = rw; hw = r; } PORTS_4[4:4];
        field { desc = "It is inferred from the word \"filter\" in the register name that frames of this class are not flooded to port port while its bit is set."; sw = rw; hw = r; } PORTS_3[3:3];
        field { desc = "It is inferred from the word \"filter\" in the register name that frames of this class are not flooded to port port while its bit is set."; sw = rw; hw = r; } PORTS_2[2:2];
        field { desc = "It is inferred from the word \"filter\" in the register name that frames of this class are not flooded to port port while its bit is set."; sw = rw; hw = r; } PORTS_1[1:1];
        field { desc = "It is inferred from the word \"filter\" in the register name that frames of this class are not flooded to port port while its bit is set."; sw = rw; hw = r; } PORTS_0[0:0];
    } FILTER_MCAST @ 0x180510;

    reg {
        name = "Broadcast flood filter";
        desc = "Ports that do not receive broadcast frames.";
        field { desc = "It is inferred from the word \"filter\" in the register name that frames of this class are not flooded to port port while its bit is set."; sw = rw; hw = r; } PORTS_10[10:10];
        field { desc = "It is inferred from the word \"filter\" in the register name that frames of this class are not flooded to port port while its bit is set."; sw = rw; hw = r; } PORTS_9[9:9];
        field { desc = "It is inferred from the word \"filter\" in the register name that frames of this class are not flooded to port port while its bit is set."; sw = rw; hw = r; } PORTS_8[8:8];
        field { desc = "It is inferred from the word \"filter\" in the register name that frames of this class are not flooded to port port while its bit is set."; sw = rw; hw = r; } PORTS_7[7:7];
        field { desc = "It is inferred from the word \"filter\" in the register name that frames of this class are not flooded to port port while its bit is set."; sw = rw; hw = r; } PORTS_6[6:6];
        field { desc = "It is inferred from the word \"filter\" in the register name that frames of this class are not flooded to port port while its bit is set."; sw = rw; hw = r; } PORTS_5[5:5];
        field { desc = "It is inferred from the word \"filter\" in the register name that frames of this class are not flooded to port port while its bit is set."; sw = rw; hw = r; } PORTS_4[4:4];
        field { desc = "It is inferred from the word \"filter\" in the register name that frames of this class are not flooded to port port while its bit is set."; sw = rw; hw = r; } PORTS_3[3:3];
        field { desc = "It is inferred from the word \"filter\" in the register name that frames of this class are not flooded to port port while its bit is set."; sw = rw; hw = r; } PORTS_2[2:2];
        field { desc = "It is inferred from the word \"filter\" in the register name that frames of this class are not flooded to port port while its bit is set."; sw = rw; hw = r; } PORTS_1[1:1];
        field { desc = "It is inferred from the word \"filter\" in the register name that frames of this class are not flooded to port port while its bit is set."; sw = rw; hw = r; } PORTS_0[0:0];
    } FILTER_BCAST @ 0x180514;

    reg {
        name = "Egress VLAN filter";
        desc = "Per-port egress VLAN membership check.";
        field { desc = "Port port sends frames only of VLANs that list it."; sw = rw; hw = r; } PORT_10[10:10];
        field { desc = "Port port sends frames only of VLANs that list it."; sw = rw; hw = r; } PORT_9[9:9];
        field { desc = "Port port sends frames only of VLANs that list it."; sw = rw; hw = r; } PORT_8[8:8];
        field { desc = "Port port sends frames only of VLANs that list it."; sw = rw; hw = r; } PORT_7[7:7];
        field { desc = "Port port sends frames only of VLANs that list it."; sw = rw; hw = r; } PORT_6[6:6];
        field { desc = "Port port sends frames only of VLANs that list it."; sw = rw; hw = r; } PORT_5[5:5];
        field { desc = "Port port sends frames only of VLANs that list it."; sw = rw; hw = r; } PORT_4[4:4];
        field { desc = "Port port sends frames only of VLANs that list it."; sw = rw; hw = r; } PORT_3[3:3];
        field { desc = "Port port sends frames only of VLANs that list it."; sw = rw; hw = r; } PORT_2[2:2];
        field { desc = "Port port sends frames only of VLANs that list it."; sw = rw; hw = r; } PORT_1[1:1];
        field { desc = "Port port sends frames only of VLANs that list it."; sw = rw; hw = r; } PORT_0[0:0];
    } VLAN_EGR_FILTER @ 0x180598;

    reg {
        name = "Link aggregation group";
        desc = "Member ports and member count of one link aggregation group. Index: lag = 0 to 1.";
        field { desc = "Member ports. Each port has one bit."; sw = rw; hw = r; } PORTS[13:3];
        field { desc = "Number of valid LAG_MEMBER slots of the group."; sw = rw; hw = r; } MEMBER_NUM[2:0];
    } LAG_GROUP[2] @ 0x1805A8 += 0x4;

    reg {
        name = "Link aggregation member slot";
        desc = "Port in one of the four member slots of a group. The hash result picks a slot. Index: lag = 0 to 1, slot = 0 to 3.";
        field { desc = "Port number in this slot."; sw = rw; hw = r; } PORT[3:0];
    } LAG_MEMBER[2][4] @ 0x1805B0 += 0x4;

    reg {
        name = "CPU copy destination";
        desc = "Chooses where frames that are trapped or copied to the CPU go.";
        field { desc = "Always send such frames to the built-in microcontroller port."; sw = rw; hw = r; } FORCE_INT_PORT[2:2];
        field { desc = "Send such frames to the built-in microcontroller on port 10."; sw = rw; hw = r; } TO_INT_CPU[1:1];
        field { desc = "Send such frames to the external CPU port set in EXT_CPU_PORT."; sw = rw; hw = r; } TO_EXT_CPU[0:0];
    } CPU_COPY @ 0x180690;

    reg {
        name = "ACL unmatched frame permit";
        desc = "Port mask for frames that match no ACL rule. yt921x_chip_setup_acl sets the bit of every port.";
        field { desc = "yt921x_chip_setup_acl sets the bit of every port. It is inferred from the register name that port port then forwards received frames that match no rule."; sw = rw; hw = r; } PORTS_10[10:10];
        field { desc = "yt921x_chip_setup_acl sets the bit of every port. It is inferred from the register name that port port then forwards received frames that match no rule."; sw = rw; hw = r; } PORTS_9[9:9];
        field { desc = "yt921x_chip_setup_acl sets the bit of every port. It is inferred from the register name that port port then forwards received frames that match no rule."; sw = rw; hw = r; } PORTS_8[8:8];
        field { desc = "yt921x_chip_setup_acl sets the bit of every port. It is inferred from the register name that port port then forwards received frames that match no rule."; sw = rw; hw = r; } PORTS_7[7:7];
        field { desc = "yt921x_chip_setup_acl sets the bit of every port. It is inferred from the register name that port port then forwards received frames that match no rule."; sw = rw; hw = r; } PORTS_6[6:6];
        field { desc = "yt921x_chip_setup_acl sets the bit of every port. It is inferred from the register name that port port then forwards received frames that match no rule."; sw = rw; hw = r; } PORTS_5[5:5];
        field { desc = "yt921x_chip_setup_acl sets the bit of every port. It is inferred from the register name that port port then forwards received frames that match no rule."; sw = rw; hw = r; } PORTS_4[4:4];
        field { desc = "yt921x_chip_setup_acl sets the bit of every port. It is inferred from the register name that port port then forwards received frames that match no rule."; sw = rw; hw = r; } PORTS_3[3:3];
        field { desc = "yt921x_chip_setup_acl sets the bit of every port. It is inferred from the register name that port port then forwards received frames that match no rule."; sw = rw; hw = r; } PORTS_2[2:2];
        field { desc = "yt921x_chip_setup_acl sets the bit of every port. It is inferred from the register name that port port then forwards received frames that match no rule."; sw = rw; hw = r; } PORTS_1[1:1];
        field { desc = "yt921x_chip_setup_acl sets the bit of every port. It is inferred from the register name that port port then forwards received frames that match no rule."; sw = rw; hw = r; } PORTS_0[0:0];
    } ACL_PERMIT_UNMATCH @ 0x1806A0;

    reg {
        name = "Unknown unicast action";
        desc = "What the switch does with a frame whose unicast destination is not in the forwarding database, chosen per receiving port.";
        enum act_unk_ucast_act_e {
            FORWARD = 0 { desc = "Flood the frame"; };
            TRAP = 1 { desc = "Send the frame to the CPU only"; };
            DROP = 2 { desc = "Discard the frame"; };
            COPY = 3 { desc = "Flood the frame and copy it to the CPU"; };
        };
        field { desc = "Action for frames received on port port."; sw = rw; hw = r; encode = act_unk_ucast_act_e; } ACT_10[21:20];
        field { desc = "Action for frames received on port port."; sw = rw; hw = r; encode = act_unk_ucast_act_e; } ACT_9[19:18];
        field { desc = "Action for frames received on port port."; sw = rw; hw = r; encode = act_unk_ucast_act_e; } ACT_8[17:16];
        field { desc = "Action for frames received on port port."; sw = rw; hw = r; encode = act_unk_ucast_act_e; } ACT_7[15:14];
        field { desc = "Action for frames received on port port."; sw = rw; hw = r; encode = act_unk_ucast_act_e; } ACT_6[13:12];
        field { desc = "Action for frames received on port port."; sw = rw; hw = r; encode = act_unk_ucast_act_e; } ACT_5[11:10];
        field { desc = "Action for frames received on port port."; sw = rw; hw = r; encode = act_unk_ucast_act_e; } ACT_4[9:8];
        field { desc = "Action for frames received on port port."; sw = rw; hw = r; encode = act_unk_ucast_act_e; } ACT_3[7:6];
        field { desc = "Action for frames received on port port."; sw = rw; hw = r; encode = act_unk_ucast_act_e; } ACT_2[5:4];
        field { desc = "Action for frames received on port port."; sw = rw; hw = r; encode = act_unk_ucast_act_e; } ACT_1[3:2];
        field { desc = "Action for frames received on port port."; sw = rw; hw = r; encode = act_unk_ucast_act_e; } ACT_0[1:0];
    } ACT_UNK_UCAST @ 0x180734;

    reg {
        name = "Unknown multicast action";
        desc = "What the switch does with a frame whose multicast destination is not in the forwarding database, chosen per receiving port.";
        enum act_unk_mcast_act_e {
            FORWARD = 0 { desc = "Flood the frame"; };
            TRAP = 1 { desc = "Send the frame to the CPU only"; };
            DROP = 2 { desc = "Discard the frame"; };
            COPY = 3 { desc = "Flood the frame and copy it to the CPU"; };
        };
        field { desc = "Reserved multicast addresses are exempt from the action ACT_UNK_MCAST.ACT.DROP."; sw = rw; hw = r; } BYPASS_DROP_RMA[23:23];
        field { desc = "IGMP frames are exempt from the action ACT_UNK_MCAST.ACT.DROP."; sw = rw; hw = r; } BYPASS_DROP_IGMP[22:22];
        field { desc = "Action for frames received on port port."; sw = rw; hw = r; encode = act_unk_mcast_act_e; } ACT_10[21:20];
        field { desc = "Action for frames received on port port."; sw = rw; hw = r; encode = act_unk_mcast_act_e; } ACT_9[19:18];
        field { desc = "Action for frames received on port port."; sw = rw; hw = r; encode = act_unk_mcast_act_e; } ACT_8[17:16];
        field { desc = "Action for frames received on port port."; sw = rw; hw = r; encode = act_unk_mcast_act_e; } ACT_7[15:14];
        field { desc = "Action for frames received on port port."; sw = rw; hw = r; encode = act_unk_mcast_act_e; } ACT_6[13:12];
        field { desc = "Action for frames received on port port."; sw = rw; hw = r; encode = act_unk_mcast_act_e; } ACT_5[11:10];
        field { desc = "Action for frames received on port port."; sw = rw; hw = r; encode = act_unk_mcast_act_e; } ACT_4[9:8];
        field { desc = "Action for frames received on port port."; sw = rw; hw = r; encode = act_unk_mcast_act_e; } ACT_3[7:6];
        field { desc = "Action for frames received on port port."; sw = rw; hw = r; encode = act_unk_mcast_act_e; } ACT_2[5:4];
        field { desc = "Action for frames received on port port."; sw = rw; hw = r; encode = act_unk_mcast_act_e; } ACT_1[3:2];
        field { desc = "Action for frames received on port port."; sw = rw; hw = r; encode = act_unk_mcast_act_e; } ACT_0[1:0];
    } ACT_UNK_MCAST @ 0x180738;

    reg {
        name = "Automatic flush";
        desc = "Lets the switch remove learned addresses on its own.";
        field { desc = "Remove the dynamic entries of a port when its link goes down."; sw = rw; hw = r; } ON_LINKDOWN[0:0];
    } FDB_HW_FLUSH @ 0x180958;

    reg {
        name = "VLAN table entry";
        desc = "One 64-bit entry per VLAN ID. Write the low word, then the high word. VLAN table shows how to build an entry. Index: vid = 0 to 4095.";
        regwidth = 64;
        field { desc = "Ports that send frames of this VLAN without a tag. Each port has one bit."; sw = rw; hw = r; } UNTAG_PORTS_10[50:50];
        field { desc = "Ports that send frames of this VLAN without a tag. Each port has one bit."; sw = rw; hw = r; } UNTAG_PORTS_9[49:49];
        field { desc = "Ports that send frames of this VLAN without a tag. Each port has one bit."; sw = rw; hw = r; } UNTAG_PORTS_8[48:48];
        field { desc = "Ports that send frames of this VLAN without a tag. Each port has one bit."; sw = rw; hw = r; } UNTAG_PORTS_7[47:47];
        field { desc = "Ports that send frames of this VLAN without a tag. Each port has one bit."; sw = rw; hw = r; } UNTAG_PORTS_6[46:46];
        field { desc = "Ports that send frames of this VLAN without a tag. Each port has one bit."; sw = rw; hw = r; } UNTAG_PORTS_5[45:45];
        field { desc = "Ports that send frames of this VLAN without a tag. Each port has one bit."; sw = rw; hw = r; } UNTAG_PORTS_4[44:44];
        field { desc = "Ports that send frames of this VLAN without a tag. Each port has one bit."; sw = rw; hw = r; } UNTAG_PORTS_3[43:43];
        field { desc = "Ports that send frames of this VLAN without a tag. Each port has one bit."; sw = rw; hw = r; } UNTAG_PORTS_2[42:42];
        field { desc = "Ports that send frames of this VLAN without a tag. Each port has one bit."; sw = rw; hw = r; } UNTAG_PORTS_1[41:41];
        field { desc = "Ports that send frames of this VLAN without a tag. Each port has one bit."; sw = rw; hw = r; } UNTAG_PORTS_0[40:40];
        field { desc = "Spanning tree instance of this VLAN. It selects the STP register."; sw = rw; hw = r; } STP_ID[39:36];
        field { desc = "No function of the Linux driver sets it, as the comment in yt921x_vlan_aware_set states. The Linux name reads as a service VLAN enable. The vendor SDK names the bit SVL_EN and sets it in fal_tiger_vlan_svlMode_enable_set(); the comment on yt_vlan_svlMode_enable_set() reads \"Set vlan svl mode.It will look up fid after enable svl.\" By that comment the bit makes the VLAN use VLAN_CTRL.FID for the address lookup, which disagrees with the reading of the Linux name."; sw = rw; hw = r; } SVLAN_EN[35:35];
        field { desc = "Filtering ID for address learning and lookup. No function of the Linux driver writes it. yt921x_fdb_in01 writes the VLAN ID to FDB_IN1.FID, so the Linux driver addresses the forwarding database by VLAN ID. The vendor SDK function fal_tiger_vlan_fid_set() writes the field, and the comment on yt_vlan_svlMode_enable_set() states that the lookup uses the filtering ID once VLAN_CTRL.SVLAN_EN is set. The field crosses the boundary between the two words."; sw = rw; hw = r; } FID[34:23];
        field { desc = "Source addresses of frames in this VLAN are not learned."; sw = rw; hw = r; } LEARN_DIS[22:22];
        field { desc = "Frames of this VLAN get the priority in VLAN_CTRL.PRIO."; sw = rw; hw = r; } PRIO_EN[21:21];
        field { desc = "VLAN priority. It is a source for PORT_PRIO_ORD."; sw = rw; hw = r; } PRIO[20:18];
        field { desc = "Member ports. Each port has one bit."; sw = rw; hw = r; } PORTS_10[17:17];
        field { desc = "Member ports. Each port has one bit."; sw = rw; hw = r; } PORTS_9[16:16];
        field { desc = "Member ports. Each port has one bit."; sw = rw; hw = r; } PORTS_8[15:15];
        field { desc = "Member ports. Each port has one bit."; sw = rw; hw = r; } PORTS_7[14:14];
        field { desc = "Member ports. Each port has one bit."; sw = rw; hw = r; } PORTS_6[13:13];
        field { desc = "Member ports. Each port has one bit."; sw = rw; hw = r; } PORTS_5[12:12];
        field { desc = "Member ports. Each port has one bit."; sw = rw; hw = r; } PORTS_4[11:11];
        field { desc = "Member ports. Each port has one bit."; sw = rw; hw = r; } PORTS_3[10:10];
        field { desc = "Member ports. Each port has one bit."; sw = rw; hw = r; } PORTS_2[9:9];
        field { desc = "Member ports. Each port has one bit."; sw = rw; hw = r; } PORTS_1[8:8];
        field { desc = "Member ports. Each port has one bit."; sw = rw; hw = r; } PORTS_0[7:7];
        field { desc = "Frames of this VLAN skip IEEE 802.1X access control."; sw = rw; hw = r; } BYPASS_1X_AC[6:6];
        field { desc = "Frames of this VLAN are rate limited by the meter in VLAN_CTRL.METER_ID. The vendor SDK function fal_tiger_rate_meter_vlan_enable_set() writes this bit and VLAN_CTRL.METER_ID to attach a meter to a VLAN."; sw = rw; hw = r; } METER_EN[5:5];
        field { desc = "Meter number. It is an index of METER_CTRL."; sw = rw; hw = r; } METER_ID[4:0];
    } VLAN_CTRL[4096] @ 0x188000 += 0x8;

    reg {
        name = "ACL action entry";
        desc = "96-bit action of one rule. The entry index is 8 × blk + the group number of the rule in ACL_ENTRY.GRPID. Write the three words in rising address order. Index: entry = 0 to 383.";
        regwidth = 128;
        enum acl_act_stag_e {
            DONTCARE = 0 { desc = "Leave to the normal VLAN rules"; };
            UNTAG = 1 { desc = "Send without the tag"; };
            TAG = 2 { desc = "Send with the tag"; };
            KEEP = 3 { desc = "Send as received"; };
        };
        enum acl_act_ctag_e {
            DONTCARE = 0 { desc = "Leave to the normal VLAN rules"; };
            UNTAG = 1 { desc = "Send without the tag"; };
            TAG = 2 { desc = "Send with the tag"; };
            KEEP = 3 { desc = "Send as received"; };
        };
        enum acl_act_fwd_e {
            FWD = 0 { desc = "Forward normally"; };
            COPY = 1 { desc = "Forward and also send to ACL_ACT.FWD_REDIR_DPORTS"; };
            REDIR = 2 { desc = "Send only to ACL_ACT.FWD_REDIR_DPORTS"; };
            TRAP = 3 { desc = "Send only to the CPU"; };
        };
        enum acl_act_color_e {
            GREEN = 0 { desc = "Green"; };
            YELLOW = 1 { desc = "Yellow"; };
            RED = 2 { desc = "Red"; };
        };
        field { desc = "Service tag handling on transmit."; sw = rw; hw = r; encode = acl_act_stag_e; } STAG[90:89];
        field { desc = "Customer tag handling on transmit."; sw = rw; hw = r; encode = acl_act_ctag_e; } CTAG[88:87];
        field { desc = "Forwarding action. It is used when ACL_ACT.FWD_EN is set."; sw = rw; hw = r; encode = acl_act_fwd_e; } FWD[86:85];
        field { desc = "Destination ports for ACL_ACT.FWD.COPY and ACL_ACT.FWD.REDIR. Each port has one bit. ACL_ACT.FWD.REDIR with no port set drops the frame."; sw = rw; hw = r; } FWD_REDIR_DPORTS_10[84:84];
        field { desc = "Destination ports for ACL_ACT.FWD.COPY and ACL_ACT.FWD.REDIR. Each port has one bit. ACL_ACT.FWD.REDIR with no port set drops the frame."; sw = rw; hw = r; } FWD_REDIR_DPORTS_9[83:83];
        field { desc = "Destination ports for ACL_ACT.FWD.COPY and ACL_ACT.FWD.REDIR. Each port has one bit. ACL_ACT.FWD.REDIR with no port set drops the frame."; sw = rw; hw = r; } FWD_REDIR_DPORTS_8[82:82];
        field { desc = "Destination ports for ACL_ACT.FWD.COPY and ACL_ACT.FWD.REDIR. Each port has one bit. ACL_ACT.FWD.REDIR with no port set drops the frame."; sw = rw; hw = r; } FWD_REDIR_DPORTS_7[81:81];
        field { desc = "Destination ports for ACL_ACT.FWD.COPY and ACL_ACT.FWD.REDIR. Each port has one bit. ACL_ACT.FWD.REDIR with no port set drops the frame."; sw = rw; hw = r; } FWD_REDIR_DPORTS_6[80:80];
        field { desc = "Destination ports for ACL_ACT.FWD.COPY and ACL_ACT.FWD.REDIR. Each port has one bit. ACL_ACT.FWD.REDIR with no port set drops the frame."; sw = rw; hw = r; } FWD_REDIR_DPORTS_5[79:79];
        field { desc = "Destination ports for ACL_ACT.FWD.COPY and ACL_ACT.FWD.REDIR. Each port has one bit. ACL_ACT.FWD.REDIR with no port set drops the frame."; sw = rw; hw = r; } FWD_REDIR_DPORTS_4[78:78];
        field { desc = "Destination ports for ACL_ACT.FWD.COPY and ACL_ACT.FWD.REDIR. Each port has one bit. ACL_ACT.FWD.REDIR with no port set drops the frame."; sw = rw; hw = r; } FWD_REDIR_DPORTS_3[77:77];
        field { desc = "Destination ports for ACL_ACT.FWD.COPY and ACL_ACT.FWD.REDIR. Each port has one bit. ACL_ACT.FWD.REDIR with no port set drops the frame."; sw = rw; hw = r; } FWD_REDIR_DPORTS_2[76:76];
        field { desc = "Destination ports for ACL_ACT.FWD.COPY and ACL_ACT.FWD.REDIR. Each port has one bit. ACL_ACT.FWD.REDIR with no port set drops the frame."; sw = rw; hw = r; } FWD_REDIR_DPORTS_1[75:75];
        field { desc = "Destination ports for ACL_ACT.FWD.COPY and ACL_ACT.FWD.REDIR. Each port has one bit. ACL_ACT.FWD.REDIR with no port set drops the frame."; sw = rw; hw = r; } FWD_REDIR_DPORTS_0[74:74];
        field { desc = "Enables the forwarding action."; sw = rw; hw = r; } FWD_EN[73:73];
        field { desc = "New drop eligible bit of the service tag."; sw = rw; hw = r; } SDEI[72:72];
        field { desc = "Replace the drop eligible bit of the service tag."; sw = rw; hw = r; } SDEI_REPLACE[71:71];
        field { desc = "New priority of the service tag."; sw = rw; hw = r; } SPRI[70:68];
        field { desc = "Replace the priority of the service tag."; sw = rw; hw = r; } SPRI_REPLACE[67:67];
        field { desc = "New service VLAN ID. The field crosses the boundary between words 1 and 2."; sw = rw; hw = r; } SVID[66:55];
        field { desc = "Replace the service VLAN ID."; sw = rw; hw = r; } SVID_REPLACE[54:54];
        field { desc = "New drop eligible bit of the customer tag."; sw = rw; hw = r; } CDEI[53:53];
        field { desc = "Replace the drop eligible bit of the customer tag."; sw = rw; hw = r; } CDEI_REPLACE[52:52];
        field { desc = "New priority of the customer tag."; sw = rw; hw = r; } CPRI[51:49];
        field { desc = "Replace the priority of the customer tag."; sw = rw; hw = r; } CPRI_REPLACE[48:48];
        field { desc = "New customer VLAN ID."; sw = rw; hw = r; } CVID[47:36];
        field { desc = "Replace the customer VLAN ID."; sw = rw; hw = r; } CVID_REPLACE[35:35];
        field { desc = "Internal priority given to the frame. It is inferred that it is a source for PORT_PRIO_ORD."; sw = rw; hw = r; } PRIO[34:32];
        field { desc = "Enables ACL_ACT.PRIO."; sw = rw; hw = r; } PRIO_EN[31:31];
        field { desc = "Colour given to the frame."; sw = rw; hw = r; encode = acl_act_color_e; } COLOR[30:29];
        field { desc = "Enables ACL_ACT.COLOR."; sw = rw; hw = r; } COLOR_EN[28:28];
        field { desc = "New IP DSCP value."; sw = rw; hw = r; } DSCP[27:22];
        field { desc = "Replace the IP DSCP value."; sw = rw; hw = r; } DSCP_REPLACE[21:21];
        field { desc = "Meter that rate limits matching frames. It is an index of METER_CTRL."; sw = rw; hw = r; } METER_ID[20:15];
        field { desc = "Enables ACL_ACT.METER_ID."; sw = rw; hw = r; } METER_EN[14:14];
        field { desc = "Copy matching frames to the monitor port in MIRROR.PORT."; sw = rw; hw = r; } MIRROR_EN[13:13];
        field { desc = "Count matching frames in the flow counter ACL_ACT.FLOWSTAT_ID."; sw = rw; hw = r; } FLOWSTAT_EN[12:12];
        field { desc = "Flow counter number."; sw = rw; hw = r; } FLOWSTAT_ID[11:6];
        field { desc = "Signal a match on the pin in ACL_ACT.GPIO_PIN."; sw = rw; hw = r; } GPIO_EN[5:5];
        field { desc = "Pin number."; sw = rw; hw = r; } GPIO_PIN[4:1];
        field { desc = "Raise an interrupt on a match."; sw = rw; hw = r; } INTR_EN[0:0];
    } ACL_ACT[384] @ 0x1C0000 += 0x10;

    reg {
        name = "ACL block keep mask";
        desc = "While a block is open, marks the key slots that the commit must leave unchanged.";
        field { desc = "Group number for slot bin during the commit."; sw = rw; hw = r; } GRPID_7[31:29];
        field { desc = "Group number for slot bin during the commit."; sw = rw; hw = r; } GRPID_6[27:25];
        field { desc = "Group number for slot bin during the commit."; sw = rw; hw = r; } GRPID_5[23:21];
        field { desc = "Group number for slot bin during the commit."; sw = rw; hw = r; } GRPID_4[19:17];
        field { desc = "Group number for slot bin during the commit."; sw = rw; hw = r; } GRPID_3[15:13];
        field { desc = "Group number for slot bin during the commit."; sw = rw; hw = r; } GRPID_2[11:9];
        field { desc = "Group number for slot bin during the commit."; sw = rw; hw = r; } GRPID_1[7:5];
        field { desc = "Group number for slot bin during the commit."; sw = rw; hw = r; } GRPID_0[3:1];
        field { desc = "Slot bin keeps its current key and mask."; sw = rw; hw = r; } KEEP_7[28:28];
        field { desc = "Slot bin keeps its current key and mask."; sw = rw; hw = r; } KEEP_6[24:24];
        field { desc = "Slot bin keeps its current key and mask."; sw = rw; hw = r; } KEEP_5[20:20];
        field { desc = "Slot bin keeps its current key and mask."; sw = rw; hw = r; } KEEP_4[16:16];
        field { desc = "Slot bin keeps its current key and mask."; sw = rw; hw = r; } KEEP_3[12:12];
        field { desc = "Slot bin keeps its current key and mask."; sw = rw; hw = r; } KEEP_2[8:8];
        field { desc = "Slot bin keeps its current key and mask."; sw = rw; hw = r; } KEEP_1[4:4];
        field { desc = "Slot bin keeps its current key and mask."; sw = rw; hw = r; } KEEP_0[0:0];
    } ACL_BLK_KEEP @ 0x201000;

    reg {
        name = "ACL port enable";
        desc = "Ports whose received frames are checked against the access control list.";
        field { desc = "The access control list is applied to port port."; sw = rw; hw = r; } PORTS_10[10:10];
        field { desc = "The access control list is applied to port port."; sw = rw; hw = r; } PORTS_9[9:9];
        field { desc = "The access control list is applied to port port."; sw = rw; hw = r; } PORTS_8[8:8];
        field { desc = "The access control list is applied to port port."; sw = rw; hw = r; } PORTS_7[7:7];
        field { desc = "The access control list is applied to port port."; sw = rw; hw = r; } PORTS_6[6:6];
        field { desc = "The access control list is applied to port port."; sw = rw; hw = r; } PORTS_5[5:5];
        field { desc = "The access control list is applied to port port."; sw = rw; hw = r; } PORTS_4[4:4];
        field { desc = "The access control list is applied to port port."; sw = rw; hw = r; } PORTS_3[3:3];
        field { desc = "The access control list is applied to port port."; sw = rw; hw = r; } PORTS_2[2:2];
        field { desc = "The access control list is applied to port port."; sw = rw; hw = r; } PORTS_1[1:1];
        field { desc = "The access control list is applied to port port."; sw = rw; hw = r; } PORTS_0[0:0];
    } ACL_PORT @ 0x202000;

    reg {
        name = "ACL block command";
        desc = "Opens one ACL block for modification and commits it; see Writing a rule.";
        field { desc = "Block number from 0 to 47."; sw = rw; hw = r; } BLKID[6:1];
        field { desc = "Write 1 to open the block for writing. Write 0 to commit the changes."; sw = rw; hw = r; } MODIFY[0:0];
    } ACL_BLK_CMD @ 0x202004;

    reg {
        name = "ACL block slot enables";
        desc = "Enables the eight key slots of one block and groups slots into rules. Slots with the same group number must all match for the rule to hit; the group number is also the slot whose ACL_ACT entry holds the action. Index: blk = 0 to 47.";
        field { desc = "Group number of slot bin. The slots of one rule share a group number."; sw = rw; hw = r; } GRPID_7[31:29];
        field { desc = "Group number of slot bin. The slots of one rule share a group number."; sw = rw; hw = r; } GRPID_6[27:25];
        field { desc = "Group number of slot bin. The slots of one rule share a group number."; sw = rw; hw = r; } GRPID_5[23:21];
        field { desc = "Group number of slot bin. The slots of one rule share a group number."; sw = rw; hw = r; } GRPID_4[19:17];
        field { desc = "Group number of slot bin. The slots of one rule share a group number."; sw = rw; hw = r; } GRPID_3[15:13];
        field { desc = "Group number of slot bin. The slots of one rule share a group number."; sw = rw; hw = r; } GRPID_2[11:9];
        field { desc = "Group number of slot bin. The slots of one rule share a group number."; sw = rw; hw = r; } GRPID_1[7:5];
        field { desc = "Group number of slot bin. The slots of one rule share a group number."; sw = rw; hw = r; } GRPID_0[3:1];
        field { desc = "Slot bin is in use."; sw = rw; hw = r; } EN_7[28:28];
        field { desc = "Slot bin is in use."; sw = rw; hw = r; } EN_6[24:24];
        field { desc = "Slot bin is in use."; sw = rw; hw = r; } EN_5[20:20];
        field { desc = "Slot bin is in use."; sw = rw; hw = r; } EN_4[16:16];
        field { desc = "Slot bin is in use."; sw = rw; hw = r; } EN_3[12:12];
        field { desc = "Slot bin is in use."; sw = rw; hw = r; } EN_2[8:8];
        field { desc = "Slot bin is in use."; sw = rw; hw = r; } EN_1[4:4];
        field { desc = "Slot bin is in use."; sw = rw; hw = r; } EN_0[0:0];
    } ACL_ENTRY[48] @ 0x203000 += 0x4;

    regfile {
        name = "ACL key slot, one value of index bin";
        reg {
            name = "ACL key slot";
            desc = "Value half of one key slot. Index blk is the block and bin the slot in the block. The layout of bits 35 to 0 and of the range flags depends on ACL_KEY.TYPE. Index: blk = 0 to 47, bin = 0 to 7.";
            regwidth = 64;
            enum acl_key_type_e {
                NA = 0 { desc = "Slot not used"; };
                MAC_DA0 = 1 { desc = "Destination MAC address bits 47 to 16"; };
                MAC_SA0 = 2 { desc = "Source MAC address bits 47 to 16"; };
                MAC_DA1_SA1 = 3 { desc = "Destination and source MAC address bits 15 to 0"; };
                VLAN = 4 { desc = "VLAN identifiers and priorities with tag format"; };
                VTAG = 5 { desc = "VLAN identifiers and priorities"; };
                IPV4_DA = 6 { desc = "IPv4 destination address"; };
                IPV4_SA = 7 { desc = "IPv4 source address"; };
                IPV6_DA0 = 8 { desc = "IPv6 destination address bits 127 to 96"; };
                IPV6_DA1 = 9 { desc = "IPv6 destination address bits 95 to 64"; };
                IPV6_DA2 = 10 { desc = "IPv6 destination address bits 63 to 32"; };
                IPV6_DA3 = 11 { desc = "IPv6 destination address bits 31 to 0"; };
                IPV6_SA0 = 12 { desc = "IPv6 source address bits 127 to 96"; };
                IPV6_SA1 = 13 { desc = "IPv6 source address bits 95 to 64"; };
                IPV6_SA2 = 14 { desc = "IPv6 source address bits 63 to 32"; };
                IPV6_SA3 = 15 { desc = "IPv6 source address bits 31 to 0"; };
                MISC = 16 { desc = "IP and TCP header fields. The fields are the IP protocol and the type of service and the TCP flags and the frame class"; };
                L4 = 17 { desc = "TCP or UDP source and destination ports"; };
                UDF0 = 18 { desc = "User-defined field windows 0 and 1"; };
                UDF1 = 19 { desc = "User-defined field windows 2 and 3"; };
                UDF2 = 20 { desc = "User-defined field windows 4 and 5"; };
                UDF3 = 21 { desc = "User-defined field windows 6 and 7"; };
                UDF4 = 22 { desc = "User-defined field windows 8 and 9"; };
                UDF5 = 23 { desc = "User-defined field windows 10 and 11"; };
                UDF6 = 24 { desc = "User-defined field windows 12 and 13"; };
                UDF7 = 25 { desc = "User-defined field windows 14 and 15"; };
                ETHERTYPE = 26 { desc = "EtherType"; };
            };
            field { desc = "Order of the rule. When several rules match, the highest value wins."; sw = rw; hw = r; } ORD[61:53];
            field { desc = "Receiving ports the rule applies to. Each port has one bit."; sw = rw; hw = r; } SPORTS_10[52:52];
            field { desc = "Receiving ports the rule applies to. Each port has one bit."; sw = rw; hw = r; } SPORTS_9[51:51];
            field { desc = "Receiving ports the rule applies to. Each port has one bit."; sw = rw; hw = r; } SPORTS_8[50:50];
            field { desc = "Receiving ports the rule applies to. Each port has one bit."; sw = rw; hw = r; } SPORTS_7[49:49];
            field { desc = "Receiving ports the rule applies to. Each port has one bit."; sw = rw; hw = r; } SPORTS_6[48:48];
            field { desc = "Receiving ports the rule applies to. Each port has one bit."; sw = rw; hw = r; } SPORTS_5[47:47];
            field { desc = "Receiving ports the rule applies to. Each port has one bit."; sw = rw; hw = r; } SPORTS_4[46:46];
            field { desc = "Receiving ports the rule applies to. Each port has one bit."; sw = rw; hw = r; } SPORTS_3[45:45];
            field { desc = "Receiving ports the rule applies to. Each port has one bit."; sw = rw; hw = r; } SPORTS_2[44:44];
            field { desc = "Receiving ports the rule applies to. Each port has one bit."; sw = rw; hw = r; } SPORTS_1[43:43];
            field { desc = "Receiving ports the rule applies to. Each port has one bit."; sw = rw; hw = r; } SPORTS_0[42:42];
            field { desc = "The slot matches when the frame does not match the key."; sw = rw; hw = r; } REVERSE[41:41];
            field { desc = "Key type. It selects the layout of the rest of the slot."; sw = rw; hw = r; encode = acl_key_type_e; } TYPE[40:36];
            field { desc = "Meaning depends on the key type; see the ACL key layouts in the documentation."; sw = rw; hw = r; } LAYOUT_62[63:62];
            field { desc = "Meaning depends on the key type; see the ACL key layouts in the documentation."; sw = rw; hw = r; } LAYOUT_0[35:0];
        } BLK[48] @ 0x0 += 0x8;
    } ACL_KEY[8] @ 0x204000 += 0x200;

    regfile {
        name = "ACL mask slot, one value of index bin";
        reg {
            name = "ACL mask slot";
            desc = "Mask half of one key slot. A set bit means the same bit of ACL_KEY must match; the layouts are those of the key. For a field matched as a range the mask holds the highest value. Index: blk = 0 to 47, bin = 0 to 7.";
            regwidth = 64;
            field { desc = "Meaning depends on the key type; see the ACL key layouts in the documentation."; sw = rw; hw = r; } LAYOUT_0[35:0];
        } BLK[48] @ 0x0 += 0x8;
    } ACL_MASK[8] @ 0x205000 += 0x200;

    reg {
        name = "Ingress tag protocol identifiers";
        desc = "Four tag protocol identifier values the parser can recognise as a VLAN tag. PORT_IGR_TPID chooses which of them each port accepts. Index: n = 0 to 3.";
        field { desc = "Tag protocol identifier. An example is 0x8100."; sw = rw; hw = r; } TPID[15:0];
    } TPID_IGR[4] @ 0x210000 += 0x4;

    reg {
        name = "Port ingress tag recognition";
        desc = "yt921x_vlan_aware_set writes the register to make a port VLAN-aware or VLAN-unaware. It is inferred from the names that the register chooses which TPID_IGR entries one port treats as a customer tag and which as a service tag. VLAN-aware and VLAN-unaware ports shows how this makes a port ignore VLAN tags. Index: port = 0 to 10.";
        field { desc = "It is inferred from the names that entry n of TPID_IGR marks a service tag on this port."; sw = rw; hw = r; } STAG_3[7:7];
        field { desc = "It is inferred from the names that entry n of TPID_IGR marks a service tag on this port."; sw = rw; hw = r; } STAG_2[6:6];
        field { desc = "It is inferred from the names that entry n of TPID_IGR marks a service tag on this port."; sw = rw; hw = r; } STAG_1[5:5];
        field { desc = "It is inferred from the names that entry n of TPID_IGR marks a service tag on this port."; sw = rw; hw = r; } STAG_0[4:4];
        field { desc = "It is inferred from the names that entry n of TPID_IGR marks a customer tag on this port."; sw = rw; hw = r; } CTAG_3[3:3];
        field { desc = "It is inferred from the names that entry n of TPID_IGR marks a customer tag on this port."; sw = rw; hw = r; } CTAG_2[2:2];
        field { desc = "It is inferred from the names that entry n of TPID_IGR marks a customer tag on this port."; sw = rw; hw = r; } CTAG_1[1:1];
        field { desc = "It is inferred from the names that entry n of TPID_IGR marks a customer tag on this port."; sw = rw; hw = r; } CTAG_0[0:0];
    } PORT_IGR_TPID[11] @ 0x210010 += 0x4;

    reg {
        name = "Link aggregation hash inputs";
        desc = "Frame fields that feed the hash which spreads traffic over the members of a group.";
        field { desc = "Include the layer 4 source port."; sw = rw; hw = r; } L4_SPORT[7:7];
        field { desc = "Include the layer 4 destination port."; sw = rw; hw = r; } L4_DPORT[6:6];
        field { desc = "Include the IP protocol number."; sw = rw; hw = r; } IP_PROTO[5:5];
        field { desc = "Include the IP source address."; sw = rw; hw = r; } IP_SRC[4:4];
        field { desc = "Include the IP destination address."; sw = rw; hw = r; } IP_DST[3:3];
        field { desc = "Include the source MAC address."; sw = rw; hw = r; } MAC_SA[2:2];
        field { desc = "Include the destination MAC address."; sw = rw; hw = r; } MAC_DA[1:1];
        field { desc = "Include the receiving port."; sw = rw; hw = r; } SRC_PORT[0:0];
    } LAG_HASH @ 0x210090;

    reg {
        name = "User-defined field window";
        desc = "Position of one two-byte window that ACL keys of type UDF can match. Key type UDFk matches windows 2k and 2k + 1. Index: n = 0 to 15.";
        enum udf_ctrl_udf_type_e {
            L2 = 0 { desc = "Start of the Ethernet header"; };
            L3 = 1 { desc = "Start of the layer 3 header"; };
            L4 = 2 { desc = "Start of the layer 4 header"; };
        };
        field { desc = "Header the offset is counted from."; sw = rw; hw = r; encode = udf_ctrl_udf_type_e; } UDF_TYPE[8:7];
        field { desc = "Offset in bytes of the two-byte window from the start of that header."; sw = rw; hw = r; } UDF_OFFSET[6:0];
    } UDF_CTRL[16] @ 0x210094 += 0x4;

    reg {
        name = "Port rate accounting";
        desc = "Per-frame overhead that rate limiting adds to the frame length. Index: port = 0 to 10.";
        field { desc = "Bytes added per frame for preamble and inter-frame gap. A meter adds them when METER_CTRL.BYTE_MODE_INCLUDE_GAP is set."; sw = rw; hw = r; } GAP_VALUE[4:0];
    } PORT_RATE[11] @ 0x220000 += 0x4;

    reg {
        name = "Meter time slot";
        desc = "Period at which every meter adds tokens to its buckets.";
        field { desc = "Slot length in units of eight core clock periods. SYS_CLK shows the core clock. The smallest allowed value is 80."; sw = rw; hw = r; } SLOT[11:0];
    } METER_SLOT @ 0x220104;

    reg {
        name = "Port ingress meter";
        desc = "Attaches one of the per-port meters to the receive side of a port. Index: port = 0 to 10.";
        field { desc = "Enables ingress rate limiting on the port."; sw = rw; hw = r; } EN[4:4];
        field { desc = "Port meter number n. The meter is entry 64 + n of METER_CTRL."; sw = rw; hw = r; } ID[3:0];
    } PORT_METER[11] @ 0x220108 += 0x4;

    reg {
        name = "Meter configuration";
        desc = "96-bit configuration of one two-rate token bucket meter. Entries 0 to 63 are general-purpose meters, which :ref:`rate-meter` attaches to ACL rules and VLANs; entries 64 to 74 are the per-port meters. Token arithmetic gives the conversion from bit rates. Index: meter = 0 to 74.";
        regwidth = 128;
        enum meter_ctrl_drop_e {
            GYR = 0 { desc = "Drop every frame"; };
            YR = 1 { desc = "Drop yellow and red frames"; };
            R = 2 { desc = "Drop red frames"; };
            NONE = 3 { desc = "Drop nothing and only colour the frame"; };
        };
        field { desc = "Enables the meter."; sw = rw; hw = r; } METER_EN[78:78];
        field { desc = "Tokens that overflow the committed bucket spill into the excess bucket. This meaning is inferred from a comment. The comment on the field reads \"RFC4115: yellow use unused green bw\"."; sw = rw; hw = r; } TOKEN_OVERFLOW_EN[77:77];
        field { desc = "Colours that are dropped."; sw = rw; hw = r; encode = meter_ctrl_drop_e; } DROP[76:75];
        field { desc = "Ignore the colour the frame already has."; sw = rw; hw = r; } COLOR_BLIND[74:74];
        field { desc = "Token scale. Every token value is multiplied by 4 to the power of this field."; sw = rw; hw = r; } UNIT[73:71];
        field { desc = "Add PORT_RATE.GAP_VALUE bytes to each frame in byte mode."; sw = rw; hw = r; } BYTE_MODE_INCLUDE_GAP[70:70];
        field { desc = "Meter packets. Value 0 meters bytes."; sw = rw; hw = r; } PKT_MODE[69:69];
        field { desc = "Select the algorithm of RFC 2698. Value 0 selects that of RFC 4115."; sw = rw; hw = r; } RFC2698[68:68];
        field { desc = "Committed burst size in tokens. The field crosses the boundary between words 1 and 2."; sw = rw; hw = r; } CBS[67:52];
        field { desc = "Committed information rate in tokens per time slot."; sw = rw; hw = r; } CIR[51:34];
        field { desc = "Excess burst size in tokens. The field crosses the boundary between words 0 and 1."; sw = rw; hw = r; } EBS[33:18];
        field { desc = "Excess information rate in tokens per time slot."; sw = rw; hw = r; } EIR[17:0];
    } METER_CTRL[75] @ 0x220800 += 0x10;

    reg {
        name = "Meter token state";
        desc = "Current token counts of one meter. The bit layout is not known. Index: meter = 0 to 74.";
        regwidth = 64;
        field { desc = "Layout not known."; sw = r; hw = w; } VALUE[63:0];
    } METER_STAT[75] @ 0x221000 += 0x8;

    reg {
        name = "Port default VLAN";
        desc = "VLAN IDs and priorities given to frames that arrive on a port without the matching tag. Index: port = 0 to 10.";
        field { desc = "The Linux name reads as: use PORT_VLAN_CTRL.SVLAN_PRIO as the default service tag priority. The vendor SDK names the bit PRIORITY_TAG_SVID_EN, which reads as: give the default service VLAN ID to a priority-tagged frame. No code of either source uses the bit, and it is not known which reading is right."; sw = rw; hw = r; } SVLAN_PRIO_EN[31:31];
        field { desc = "The Linux name reads as: use PORT_VLAN_CTRL.CVLAN_PRIO as the default customer tag priority. The vendor SDK names the bit PRIORITY_TAG_CVID_EN, which reads as: give the default customer VLAN ID to a priority-tagged frame. No code of either source uses the bit, and it is not known which reading is right."; sw = rw; hw = r; } CVLAN_PRIO_EN[30:30];
        field { desc = "Default service VLAN ID."; sw = rw; hw = r; } SVID[29:18];
        field { desc = "Default customer VLAN ID (the port VLAN ID)."; sw = rw; hw = r; } CVID[17:6];
        field { desc = "Default service tag priority."; sw = rw; hw = r; } SVLAN_PRIO[5:3];
        field { desc = "Default customer tag priority."; sw = rw; hw = r; } CVLAN_PRIO[2:0];
    } PORT_VLAN_CTRL[11] @ 0x230010 += 0x4;

    reg {
        name = "Port acceptable frame types";
        desc = "Drops tagged or untagged frames on receive, per tag kind. Index: port = 0 to 10.";
        field { desc = "The Linux name reads as an enable of VLAN range matching with the profile in PORT_VLAN_CTRL1.VLAN_RANGE_PROFILE_ID. The vendor SDK names the bit VLAN_RANGE_MODE, and fal_tiger_vlan_trans_mode_set() writes a value of the list yt_vlan_range_trans_mode_t to it: 0 for the customer tag and 1 for the service tag. By that code the bit selects the tag that range matching uses, which disagrees with the Linux name. It is not known which is right."; sw = rw; hw = r; } VLAN_RANGE_EN[8:8];
        field { desc = "VLAN range profile number."; sw = rw; hw = r; } VLAN_RANGE_PROFILE_ID[7:4];
        field { desc = "Drop received frames that carry a service tag."; sw = rw; hw = r; } SVLAN_DROP_TAGGED[3:3];
        field { desc = "Drop received frames that carry no service tag."; sw = rw; hw = r; } SVLAN_DROP_UNTAGGED[2:2];
        field { desc = "yt921x_vlan_filtering always clears the bit. It is inferred from the name that a set bit drops received frames that carry a customer tag."; sw = rw; hw = r; } CVLAN_DROP_TAGGED[1:1];
        field { desc = "Drop received frames that carry no customer tag."; sw = rw; hw = r; } CVLAN_DROP_UNTAGGED[0:0];
    } PORT_VLAN_CTRL1[11] @ 0x230080 += 0x4;

    reg {
        name = "Port mirroring";
        desc = "Source ports and the single monitor port of port mirroring.";
        field { desc = "Ports whose received frames are copied to the monitor port. Each port has one bit."; sw = rw; hw = r; } IGR_PORTS_10[26:26];
        field { desc = "Ports whose received frames are copied to the monitor port. Each port has one bit."; sw = rw; hw = r; } IGR_PORTS_9[25:25];
        field { desc = "Ports whose received frames are copied to the monitor port. Each port has one bit."; sw = rw; hw = r; } IGR_PORTS_8[24:24];
        field { desc = "Ports whose received frames are copied to the monitor port. Each port has one bit."; sw = rw; hw = r; } IGR_PORTS_7[23:23];
        field { desc = "Ports whose received frames are copied to the monitor port. Each port has one bit."; sw = rw; hw = r; } IGR_PORTS_6[22:22];
        field { desc = "Ports whose received frames are copied to the monitor port. Each port has one bit."; sw = rw; hw = r; } IGR_PORTS_5[21:21];
        field { desc = "Ports whose received frames are copied to the monitor port. Each port has one bit."; sw = rw; hw = r; } IGR_PORTS_4[20:20];
        field { desc = "Ports whose received frames are copied to the monitor port. Each port has one bit."; sw = rw; hw = r; } IGR_PORTS_3[19:19];
        field { desc = "Ports whose received frames are copied to the monitor port. Each port has one bit."; sw = rw; hw = r; } IGR_PORTS_2[18:18];
        field { desc = "Ports whose received frames are copied to the monitor port. Each port has one bit."; sw = rw; hw = r; } IGR_PORTS_1[17:17];
        field { desc = "Ports whose received frames are copied to the monitor port. Each port has one bit."; sw = rw; hw = r; } IGR_PORTS_0[16:16];
        field { desc = "Ports whose sent frames are copied to the monitor port. Each port has one bit."; sw = rw; hw = r; } EGR_PORTS_10[14:14];
        field { desc = "Ports whose sent frames are copied to the monitor port. Each port has one bit."; sw = rw; hw = r; } EGR_PORTS_9[13:13];
        field { desc = "Ports whose sent frames are copied to the monitor port. Each port has one bit."; sw = rw; hw = r; } EGR_PORTS_8[12:12];
        field { desc = "Ports whose sent frames are copied to the monitor port. Each port has one bit."; sw = rw; hw = r; } EGR_PORTS_7[11:11];
        field { desc = "Ports whose sent frames are copied to the monitor port. Each port has one bit."; sw = rw; hw = r; } EGR_PORTS_6[10:10];
        field { desc = "Ports whose sent frames are copied to the monitor port. Each port has one bit."; sw = rw; hw = r; } EGR_PORTS_5[9:9];
        field { desc = "Ports whose sent frames are copied to the monitor port. Each port has one bit."; sw = rw; hw = r; } EGR_PORTS_4[8:8];
        field { desc = "Ports whose sent frames are copied to the monitor port. Each port has one bit."; sw = rw; hw = r; } EGR_PORTS_3[7:7];
        field { desc = "Ports whose sent frames are copied to the monitor port. Each port has one bit."; sw = rw; hw = r; } EGR_PORTS_2[6:6];
        field { desc = "Ports whose sent frames are copied to the monitor port. Each port has one bit."; sw = rw; hw = r; } EGR_PORTS_1[5:5];
        field { desc = "Ports whose sent frames are copied to the monitor port. Each port has one bit."; sw = rw; hw = r; } EGR_PORTS_0[4:4];
        field { desc = "Monitor port number."; sw = rw; hw = r; } PORT[3:0];
    } MIRROR @ 0x300300;

    reg {
        name = "Shaper time slot";
        desc = "Period at which every port shaper adds tokens to its bucket.";
        field { desc = "Slot length in units of eight core clock periods. SYS_CLK shows the core clock. The smallest allowed value is 80."; sw = rw; hw = r; } SLOT[11:0];
    } PORT_SHAPE_SLOT @ 0x34000C;

    reg {
        name = "Port egress shaper";
        desc = "64-bit configuration of the single token bucket that limits what one port sends. Token arithmetic gives the conversion from bit rates. Index: port = 0 to 10.";
        regwidth = 64;
        field { desc = "Enables the shaper."; sw = rw; hw = r; } EN[36:36];
        field { desc = "Shape packets. Value 0 shapes bytes."; sw = rw; hw = r; } PKT_MODE[35:35];
        field { desc = "Token scale. Every token value is multiplied by 4 to the power of this field."; sw = rw; hw = r; } UNIT[34:32];
        field { desc = "Burst size in tokens."; sw = rw; hw = r; } CBS[31:18];
        field { desc = "Rate in tokens per time slot."; sw = rw; hw = r; } CIR[17:0];
    } PORT_SHAPE_CTRL[11] @ 0x354000 += 0x8;

    reg {
        name = "Port shaper token state";
        desc = "Current token count of one port shaper. The bit layout is not known. Index: port = 0 to 10.";
        field { desc = "Layout not known."; sw = r; hw = w; } VALUE[31:0];
    } PORT_SHAPE_STAT[11] @ 0x356000 += 0x4;
};
